* NGSPICE file created from audio_soc_top.ext - technology: sky130A

* Black-box entry subcircuit for sky130_fd_sc_hd__tapvpwrvgnd_1 abstract view
.subckt sky130_fd_sc_hd__tapvpwrvgnd_1 VGND VPWR
.ends

* Black-box entry subcircuit for sky130_fd_sc_hd__a22o_1 abstract view
.subckt sky130_fd_sc_hd__a22o_1 A1 A2 B1 B2 VGND VNB VPB VPWR X
.ends

* Black-box entry subcircuit for sky130_fd_sc_hd__and4_1 abstract view
.subckt sky130_fd_sc_hd__and4_1 A B C D VGND VNB VPB VPWR X
.ends

* Black-box entry subcircuit for sky130_ef_sc_hd__decap_12 abstract view
.subckt sky130_ef_sc_hd__decap_12 VPWR VGND VPB VNB
.ends

* Black-box entry subcircuit for sky130_fd_sc_hd__fill_1 abstract view
.subckt sky130_fd_sc_hd__fill_1 VGND VNB VPB VPWR
.ends

* Black-box entry subcircuit for sky130_fd_sc_hd__clkbuf_1 abstract view
.subckt sky130_fd_sc_hd__clkbuf_1 A VGND VNB VPB VPWR X
.ends

* Black-box entry subcircuit for sky130_fd_sc_hd__dfxtp_1 abstract view
.subckt sky130_fd_sc_hd__dfxtp_1 CLK D VGND VNB VPB VPWR Q
.ends

* Black-box entry subcircuit for sky130_fd_sc_hd__fill_2 abstract view
.subckt sky130_fd_sc_hd__fill_2 VGND VNB VPB VPWR
.ends

* Black-box entry subcircuit for sky130_fd_sc_hd__decap_4 abstract view
.subckt sky130_fd_sc_hd__decap_4 VGND VNB VPB VPWR
.ends

* Black-box entry subcircuit for sky130_fd_sc_hd__dlygate4sd3_1 abstract view
.subckt sky130_fd_sc_hd__dlygate4sd3_1 A VGND VNB VPB VPWR X
.ends

* Black-box entry subcircuit for sky130_fd_sc_hd__decap_3 abstract view
.subckt sky130_fd_sc_hd__decap_3 VGND VNB VPB VPWR
.ends

* Black-box entry subcircuit for sky130_fd_sc_hd__a31o_1 abstract view
.subckt sky130_fd_sc_hd__a31o_1 A1 A2 A3 B1 VGND VNB VPB VPWR X
.ends

* Black-box entry subcircuit for sky130_fd_sc_hd__a21oi_1 abstract view
.subckt sky130_fd_sc_hd__a21oi_1 A1 A2 B1 VGND VNB VPB VPWR Y
.ends

* Black-box entry subcircuit for sky130_fd_sc_hd__nor4_2 abstract view
.subckt sky130_fd_sc_hd__nor4_2 A B C D VGND VNB VPB VPWR Y
.ends

* Black-box entry subcircuit for sky130_fd_sc_hd__dfxtp_2 abstract view
.subckt sky130_fd_sc_hd__dfxtp_2 CLK D VGND VNB VPB VPWR Q
.ends

* Black-box entry subcircuit for sky130_fd_sc_hd__and3b_1 abstract view
.subckt sky130_fd_sc_hd__and3b_1 A_N B C VGND VNB VPB VPWR X
.ends

* Black-box entry subcircuit for sky130_fd_sc_hd__decap_8 abstract view
.subckt sky130_fd_sc_hd__decap_8 VGND VNB VPB VPWR
.ends

* Black-box entry subcircuit for sky130_fd_sc_hd__clkbuf_4 abstract view
.subckt sky130_fd_sc_hd__clkbuf_4 A VGND VNB VPB VPWR X
.ends

* Black-box entry subcircuit for sky130_fd_sc_hd__a221o_1 abstract view
.subckt sky130_fd_sc_hd__a221o_1 A1 A2 B1 B2 C1 VGND VNB VPB VPWR X
.ends

* Black-box entry subcircuit for sky130_fd_sc_hd__decap_6 abstract view
.subckt sky130_fd_sc_hd__decap_6 VGND VNB VPB VPWR
.ends

* Black-box entry subcircuit for sky130_fd_sc_hd__o2111ai_4 abstract view
.subckt sky130_fd_sc_hd__o2111ai_4 A1 A2 B1 C1 D1 VGND VNB VPB VPWR Y
.ends

* Black-box entry subcircuit for sky130_fd_sc_hd__o2bb2a_1 abstract view
.subckt sky130_fd_sc_hd__o2bb2a_1 A1_N A2_N B1 B2 VGND VNB VPB VPWR X
.ends

* Black-box entry subcircuit for sky130_fd_sc_hd__nand4_1 abstract view
.subckt sky130_fd_sc_hd__nand4_1 A B C D VGND VNB VPB VPWR Y
.ends

* Black-box entry subcircuit for sky130_fd_sc_hd__clkbuf_8 abstract view
.subckt sky130_fd_sc_hd__clkbuf_8 A VGND VNB VPB VPWR X
.ends

* Black-box entry subcircuit for sky130_fd_sc_hd__o21ai_4 abstract view
.subckt sky130_fd_sc_hd__o21ai_4 A1 A2 B1 VGND VNB VPB VPWR Y
.ends

* Black-box entry subcircuit for sky130_fd_sc_hd__buf_4 abstract view
.subckt sky130_fd_sc_hd__buf_4 A VGND VNB VPB VPWR X
.ends

* Black-box entry subcircuit for sky130_fd_sc_hd__o21ai_1 abstract view
.subckt sky130_fd_sc_hd__o21ai_1 A1 A2 B1 VGND VNB VPB VPWR Y
.ends

* Black-box entry subcircuit for sky130_fd_sc_hd__a41o_1 abstract view
.subckt sky130_fd_sc_hd__a41o_1 A1 A2 A3 A4 B1 VGND VNB VPB VPWR X
.ends

* Black-box entry subcircuit for sky130_fd_sc_hd__buf_2 abstract view
.subckt sky130_fd_sc_hd__buf_2 A VGND VNB VPB VPWR X
.ends

* Black-box entry subcircuit for sky130_fd_sc_hd__nand3_1 abstract view
.subckt sky130_fd_sc_hd__nand3_1 A B C VGND VNB VPB VPWR Y
.ends

* Black-box entry subcircuit for sky130_fd_sc_hd__o31a_1 abstract view
.subckt sky130_fd_sc_hd__o31a_1 A1 A2 A3 B1 VGND VNB VPB VPWR X
.ends

* Black-box entry subcircuit for sky130_fd_sc_hd__a21o_1 abstract view
.subckt sky130_fd_sc_hd__a21o_1 A1 A2 B1 VGND VNB VPB VPWR X
.ends

* Black-box entry subcircuit for sky130_fd_sc_hd__xor2_1 abstract view
.subckt sky130_fd_sc_hd__xor2_1 A B VGND VNB VPB VPWR X
.ends

* Black-box entry subcircuit for sky130_fd_sc_hd__a211o_1 abstract view
.subckt sky130_fd_sc_hd__a211o_1 A1 A2 B1 C1 VGND VNB VPB VPWR X
.ends

* Black-box entry subcircuit for sky130_fd_sc_hd__o21ai_2 abstract view
.subckt sky130_fd_sc_hd__o21ai_2 A1 A2 B1 VGND VNB VPB VPWR Y
.ends

* Black-box entry subcircuit for sky130_fd_sc_hd__a31o_2 abstract view
.subckt sky130_fd_sc_hd__a31o_2 A1 A2 A3 B1 VGND VNB VPB VPWR X
.ends

* Black-box entry subcircuit for sky130_fd_sc_hd__nand2_1 abstract view
.subckt sky130_fd_sc_hd__nand2_1 A B VGND VNB VPB VPWR Y
.ends

* Black-box entry subcircuit for sky130_fd_sc_hd__or2_1 abstract view
.subckt sky130_fd_sc_hd__or2_1 A B VGND VNB VPB VPWR X
.ends

* Black-box entry subcircuit for sky130_fd_sc_hd__and4b_1 abstract view
.subckt sky130_fd_sc_hd__and4b_1 A_N B C D VGND VNB VPB VPWR X
.ends

* Black-box entry subcircuit for sky130_fd_sc_hd__o21a_1 abstract view
.subckt sky130_fd_sc_hd__o21a_1 A1 A2 B1 VGND VNB VPB VPWR X
.ends

* Black-box entry subcircuit for sky130_fd_sc_hd__nor2_2 abstract view
.subckt sky130_fd_sc_hd__nor2_2 A B VGND VNB VPB VPWR Y
.ends

* Black-box entry subcircuit for sky130_fd_sc_hd__and3_1 abstract view
.subckt sky130_fd_sc_hd__and3_1 A B C VGND VNB VPB VPWR X
.ends

* Black-box entry subcircuit for sky130_fd_sc_hd__mux2_1 abstract view
.subckt sky130_fd_sc_hd__mux2_1 A0 A1 S VGND VNB VPB VPWR X
.ends

* Black-box entry subcircuit for sky130_fd_sc_hd__o22a_1 abstract view
.subckt sky130_fd_sc_hd__o22a_1 A1 A2 B1 B2 VGND VNB VPB VPWR X
.ends

* Black-box entry subcircuit for sky130_fd_sc_hd__and2_1 abstract view
.subckt sky130_fd_sc_hd__and2_1 A B VGND VNB VPB VPWR X
.ends

* Black-box entry subcircuit for sky130_fd_sc_hd__a21oi_2 abstract view
.subckt sky130_fd_sc_hd__a21oi_2 A1 A2 B1 VGND VNB VPB VPWR Y
.ends

* Black-box entry subcircuit for sky130_fd_sc_hd__o221ai_4 abstract view
.subckt sky130_fd_sc_hd__o221ai_4 A1 A2 B1 B2 C1 VGND VNB VPB VPWR Y
.ends

* Black-box entry subcircuit for sky130_fd_sc_hd__o21bai_2 abstract view
.subckt sky130_fd_sc_hd__o21bai_2 A1 A2 B1_N VGND VNB VPB VPWR Y
.ends

* Black-box entry subcircuit for sky130_fd_sc_hd__o22a_4 abstract view
.subckt sky130_fd_sc_hd__o22a_4 A1 A2 B1 B2 VGND VNB VPB VPWR X
.ends

* Black-box entry subcircuit for sky130_fd_sc_hd__o2111a_2 abstract view
.subckt sky130_fd_sc_hd__o2111a_2 A1 A2 B1 C1 D1 VGND VNB VPB VPWR X
.ends

* Black-box entry subcircuit for sky130_fd_sc_hd__clkbuf_16 abstract view
.subckt sky130_fd_sc_hd__clkbuf_16 A VGND VNB VPB VPWR X
.ends

* Black-box entry subcircuit for sky130_fd_sc_hd__nand2b_2 abstract view
.subckt sky130_fd_sc_hd__nand2b_2 A_N B VGND VNB VPB VPWR Y
.ends

* Black-box entry subcircuit for sky130_fd_sc_hd__a32o_1 abstract view
.subckt sky130_fd_sc_hd__a32o_1 A1 A2 A3 B1 B2 VGND VNB VPB VPWR X
.ends

* Black-box entry subcircuit for sky130_fd_sc_hd__nor2_1 abstract view
.subckt sky130_fd_sc_hd__nor2_1 A B VGND VNB VPB VPWR Y
.ends

* Black-box entry subcircuit for sky130_fd_sc_hd__o211a_2 abstract view
.subckt sky130_fd_sc_hd__o211a_2 A1 A2 B1 C1 VGND VNB VPB VPWR X
.ends

* Black-box entry subcircuit for sky130_fd_sc_hd__or2b_1 abstract view
.subckt sky130_fd_sc_hd__or2b_1 A B_N VGND VNB VPB VPWR X
.ends

* Black-box entry subcircuit for sky130_fd_sc_hd__a22oi_2 abstract view
.subckt sky130_fd_sc_hd__a22oi_2 A1 A2 B1 B2 VGND VNB VPB VPWR Y
.ends

* Black-box entry subcircuit for sky130_fd_sc_hd__o311a_1 abstract view
.subckt sky130_fd_sc_hd__o311a_1 A1 A2 A3 B1 C1 VGND VNB VPB VPWR X
.ends

* Black-box entry subcircuit for sky130_fd_sc_hd__a21oi_4 abstract view
.subckt sky130_fd_sc_hd__a21oi_4 A1 A2 B1 VGND VNB VPB VPWR Y
.ends

* Black-box entry subcircuit for sky130_fd_sc_hd__nand3b_1 abstract view
.subckt sky130_fd_sc_hd__nand3b_1 A_N B C VGND VNB VPB VPWR Y
.ends

* Black-box entry subcircuit for sky130_fd_sc_hd__or3b_2 abstract view
.subckt sky130_fd_sc_hd__or3b_2 A B C_N VGND VNB VPB VPWR X
.ends

* Black-box entry subcircuit for sky130_fd_sc_hd__buf_6 abstract view
.subckt sky130_fd_sc_hd__buf_6 A VGND VNB VPB VPWR X
.ends

* Black-box entry subcircuit for sky130_fd_sc_hd__a311o_1 abstract view
.subckt sky130_fd_sc_hd__a311o_1 A1 A2 A3 B1 C1 VGND VNB VPB VPWR X
.ends

* Black-box entry subcircuit for sky130_fd_sc_hd__inv_2 abstract view
.subckt sky130_fd_sc_hd__inv_2 A VGND VNB VPB VPWR Y
.ends

* Black-box entry subcircuit for sky130_fd_sc_hd__or3_2 abstract view
.subckt sky130_fd_sc_hd__or3_2 A B C VGND VNB VPB VPWR X
.ends

* Black-box entry subcircuit for sky130_fd_sc_hd__nor4_1 abstract view
.subckt sky130_fd_sc_hd__nor4_1 A B C D VGND VNB VPB VPWR Y
.ends

* Black-box entry subcircuit for sky130_fd_sc_hd__o31ai_1 abstract view
.subckt sky130_fd_sc_hd__o31ai_1 A1 A2 A3 B1 VGND VNB VPB VPWR Y
.ends

* Black-box entry subcircuit for sky130_fd_sc_hd__o21bai_4 abstract view
.subckt sky130_fd_sc_hd__o21bai_4 A1 A2 B1_N VGND VNB VPB VPWR Y
.ends

* Black-box entry subcircuit for sky130_fd_sc_hd__a211oi_1 abstract view
.subckt sky130_fd_sc_hd__a211oi_1 A1 A2 B1 C1 VGND VNB VPB VPWR Y
.ends

* Black-box entry subcircuit for sky130_fd_sc_hd__o21bai_1 abstract view
.subckt sky130_fd_sc_hd__o21bai_1 A1 A2 B1_N VGND VNB VPB VPWR Y
.ends

* Black-box entry subcircuit for sky130_fd_sc_hd__a2bb2o_2 abstract view
.subckt sky130_fd_sc_hd__a2bb2o_2 A1_N A2_N B1 B2 VGND VNB VPB VPWR X
.ends

* Black-box entry subcircuit for sky130_fd_sc_hd__o221a_2 abstract view
.subckt sky130_fd_sc_hd__o221a_2 A1 A2 B1 B2 C1 VGND VNB VPB VPWR X
.ends

* Black-box entry subcircuit for sky130_fd_sc_hd__a21o_4 abstract view
.subckt sky130_fd_sc_hd__a21o_4 A1 A2 B1 VGND VNB VPB VPWR X
.ends

* Black-box entry subcircuit for sky130_fd_sc_hd__a2111o_1 abstract view
.subckt sky130_fd_sc_hd__a2111o_1 A1 A2 B1 C1 D1 VGND VNB VPB VPWR X
.ends

* Black-box entry subcircuit for sky130_fd_sc_hd__o221a_1 abstract view
.subckt sky130_fd_sc_hd__o221a_1 A1 A2 B1 B2 C1 VGND VNB VPB VPWR X
.ends

* Black-box entry subcircuit for sky130_fd_sc_hd__a2bb2o_1 abstract view
.subckt sky130_fd_sc_hd__a2bb2o_1 A1_N A2_N B1 B2 VGND VNB VPB VPWR X
.ends

* Black-box entry subcircuit for sky130_fd_sc_hd__xor2_2 abstract view
.subckt sky130_fd_sc_hd__xor2_2 A B VGND VNB VPB VPWR X
.ends

* Black-box entry subcircuit for sky130_fd_sc_hd__o211ai_1 abstract view
.subckt sky130_fd_sc_hd__o211ai_1 A1 A2 B1 C1 VGND VNB VPB VPWR Y
.ends

* Black-box entry subcircuit for sky130_fd_sc_hd__o2111a_1 abstract view
.subckt sky130_fd_sc_hd__o2111a_1 A1 A2 B1 C1 D1 VGND VNB VPB VPWR X
.ends

* Black-box entry subcircuit for sky130_fd_sc_hd__o2bb2ai_1 abstract view
.subckt sky130_fd_sc_hd__o2bb2ai_1 A1_N A2_N B1 B2 VGND VNB VPB VPWR Y
.ends

* Black-box entry subcircuit for sky130_fd_sc_hd__a22oi_1 abstract view
.subckt sky130_fd_sc_hd__a22oi_1 A1 A2 B1 B2 VGND VNB VPB VPWR Y
.ends

* Black-box entry subcircuit for sky130_fd_sc_hd__nand4_2 abstract view
.subckt sky130_fd_sc_hd__nand4_2 A B C D VGND VNB VPB VPWR Y
.ends

* Black-box entry subcircuit for sky130_fd_sc_hd__or4_2 abstract view
.subckt sky130_fd_sc_hd__or4_2 A B C D VGND VNB VPB VPWR X
.ends

* Black-box entry subcircuit for sky130_fd_sc_hd__nand4b_2 abstract view
.subckt sky130_fd_sc_hd__nand4b_2 A_N B C D VGND VNB VPB VPWR Y
.ends

* Black-box entry subcircuit for sky130_fd_sc_hd__dfrtp_1 abstract view
.subckt sky130_fd_sc_hd__dfrtp_1 CLK D RESET_B VGND VNB VPB VPWR Q
.ends

* Black-box entry subcircuit for sky130_fd_sc_hd__nor3_1 abstract view
.subckt sky130_fd_sc_hd__nor3_1 A B C VGND VNB VPB VPWR Y
.ends

* Black-box entry subcircuit for sky130_fd_sc_hd__dfrtp_4 abstract view
.subckt sky130_fd_sc_hd__dfrtp_4 CLK D RESET_B VGND VNB VPB VPWR Q
.ends

* Black-box entry subcircuit for sky130_fd_sc_hd__or3_1 abstract view
.subckt sky130_fd_sc_hd__or3_1 A B C VGND VNB VPB VPWR X
.ends

* Black-box entry subcircuit for sky130_fd_sc_hd__and3_2 abstract view
.subckt sky130_fd_sc_hd__and3_2 A B C VGND VNB VPB VPWR X
.ends

* Black-box entry subcircuit for sky130_fd_sc_hd__o31ai_2 abstract view
.subckt sky130_fd_sc_hd__o31ai_2 A1 A2 A3 B1 VGND VNB VPB VPWR Y
.ends

* Black-box entry subcircuit for sky130_fd_sc_hd__a221o_2 abstract view
.subckt sky130_fd_sc_hd__a221o_2 A1 A2 B1 B2 C1 VGND VNB VPB VPWR X
.ends

* Black-box entry subcircuit for sky130_fd_sc_hd__clkbuf_2 abstract view
.subckt sky130_fd_sc_hd__clkbuf_2 A VGND VNB VPB VPWR X
.ends

* Black-box entry subcircuit for sky130_fd_sc_hd__nor3b_2 abstract view
.subckt sky130_fd_sc_hd__nor3b_2 A B C_N VGND VNB VPB VPWR Y
.ends

* Black-box entry subcircuit for sky130_fd_sc_hd__dfrtp_2 abstract view
.subckt sky130_fd_sc_hd__dfrtp_2 CLK D RESET_B VGND VNB VPB VPWR Q
.ends

* Black-box entry subcircuit for sky130_fd_sc_hd__a311oi_1 abstract view
.subckt sky130_fd_sc_hd__a311oi_1 A1 A2 A3 B1 C1 VGND VNB VPB VPWR Y
.ends

* Black-box entry subcircuit for sky130_fd_sc_hd__o221ai_1 abstract view
.subckt sky130_fd_sc_hd__o221ai_1 A1 A2 B1 B2 C1 VGND VNB VPB VPWR Y
.ends

* Black-box entry subcircuit for sky130_fd_sc_hd__clkinv_4 abstract view
.subckt sky130_fd_sc_hd__clkinv_4 A VGND VNB VPB VPWR Y
.ends

* Black-box entry subcircuit for sky130_fd_sc_hd__or4b_1 abstract view
.subckt sky130_fd_sc_hd__or4b_1 A B C D_N VGND VNB VPB VPWR X
.ends

* Black-box entry subcircuit for sky130_fd_sc_hd__o211a_1 abstract view
.subckt sky130_fd_sc_hd__o211a_1 A1 A2 B1 C1 VGND VNB VPB VPWR X
.ends

* Black-box entry subcircuit for sky130_fd_sc_hd__o2111ai_2 abstract view
.subckt sky130_fd_sc_hd__o2111ai_2 A1 A2 B1 C1 D1 VGND VNB VPB VPWR Y
.ends

* Black-box entry subcircuit for sky130_fd_sc_hd__a31oi_4 abstract view
.subckt sky130_fd_sc_hd__a31oi_4 A1 A2 A3 B1 VGND VNB VPB VPWR Y
.ends

* Black-box entry subcircuit for sky130_fd_sc_hd__a2111oi_1 abstract view
.subckt sky130_fd_sc_hd__a2111oi_1 A1 A2 B1 C1 D1 VGND VNB VPB VPWR Y
.ends

* Black-box entry subcircuit for sky130_fd_sc_hd__a21boi_4 abstract view
.subckt sky130_fd_sc_hd__a21boi_4 A1 A2 B1_N VGND VNB VPB VPWR Y
.ends

* Black-box entry subcircuit for sky130_fd_sc_hd__a2bb2oi_1 abstract view
.subckt sky130_fd_sc_hd__a2bb2oi_1 A1_N A2_N B1 B2 VGND VNB VPB VPWR Y
.ends

* Black-box entry subcircuit for sky130_fd_sc_hd__a41oi_4 abstract view
.subckt sky130_fd_sc_hd__a41oi_4 A1 A2 A3 A4 B1 VGND VNB VPB VPWR Y
.ends

* Black-box entry subcircuit for sky130_fd_sc_hd__o31ai_4 abstract view
.subckt sky130_fd_sc_hd__o31ai_4 A1 A2 A3 B1 VGND VNB VPB VPWR Y
.ends

* Black-box entry subcircuit for sky130_fd_sc_hd__nand4_4 abstract view
.subckt sky130_fd_sc_hd__nand4_4 A B C D VGND VNB VPB VPWR Y
.ends

* Black-box entry subcircuit for sky130_fd_sc_hd__o22ai_4 abstract view
.subckt sky130_fd_sc_hd__o22ai_4 A1 A2 B1 B2 VGND VNB VPB VPWR Y
.ends

* Black-box entry subcircuit for sky130_fd_sc_hd__o22a_2 abstract view
.subckt sky130_fd_sc_hd__o22a_2 A1 A2 B1 B2 VGND VNB VPB VPWR X
.ends

* Black-box entry subcircuit for sky130_fd_sc_hd__o211ai_2 abstract view
.subckt sky130_fd_sc_hd__o211ai_2 A1 A2 B1 C1 VGND VNB VPB VPWR Y
.ends

* Black-box entry subcircuit for sky130_fd_sc_hd__nand4b_4 abstract view
.subckt sky130_fd_sc_hd__nand4b_4 A_N B C D VGND VNB VPB VPWR Y
.ends

* Black-box entry subcircuit for sky130_fd_sc_hd__dfstp_1 abstract view
.subckt sky130_fd_sc_hd__dfstp_1 CLK D SET_B VGND VNB VPB VPWR Q
.ends

* Black-box entry subcircuit for sky130_fd_sc_hd__and4_2 abstract view
.subckt sky130_fd_sc_hd__and4_2 A B C D VGND VNB VPB VPWR X
.ends

* Black-box entry subcircuit for sky130_fd_sc_hd__o32a_1 abstract view
.subckt sky130_fd_sc_hd__o32a_1 A1 A2 A3 B1 B2 VGND VNB VPB VPWR X
.ends

* Black-box entry subcircuit for sky130_fd_sc_hd__nand3_2 abstract view
.subckt sky130_fd_sc_hd__nand3_2 A B C VGND VNB VPB VPWR Y
.ends

* Black-box entry subcircuit for sky130_fd_sc_hd__or4_1 abstract view
.subckt sky130_fd_sc_hd__or4_1 A B C D VGND VNB VPB VPWR X
.ends

* Black-box entry subcircuit for sky130_fd_sc_hd__a21boi_2 abstract view
.subckt sky130_fd_sc_hd__a21boi_2 A1 A2 B1_N VGND VNB VPB VPWR Y
.ends

* Black-box entry subcircuit for sky130_fd_sc_hd__o211ai_4 abstract view
.subckt sky130_fd_sc_hd__o211ai_4 A1 A2 B1 C1 VGND VNB VPB VPWR Y
.ends

* Black-box entry subcircuit for sky130_fd_sc_hd__buf_1 abstract view
.subckt sky130_fd_sc_hd__buf_1 A VGND VNB VPB VPWR X
.ends

* Black-box entry subcircuit for sky130_fd_sc_hd__a211oi_2 abstract view
.subckt sky130_fd_sc_hd__a211oi_2 A1 A2 B1 C1 VGND VNB VPB VPWR Y
.ends

* Black-box entry subcircuit for sky130_fd_sc_hd__a21boi_1 abstract view
.subckt sky130_fd_sc_hd__a21boi_1 A1 A2 B1_N VGND VNB VPB VPWR Y
.ends

* Black-box entry subcircuit for sky130_fd_sc_hd__nand3b_2 abstract view
.subckt sky130_fd_sc_hd__nand3b_2 A_N B C VGND VNB VPB VPWR Y
.ends

* Black-box entry subcircuit for sky130_fd_sc_hd__nand3b_4 abstract view
.subckt sky130_fd_sc_hd__nand3b_4 A_N B C VGND VNB VPB VPWR Y
.ends

* Black-box entry subcircuit for sky130_fd_sc_hd__or3b_1 abstract view
.subckt sky130_fd_sc_hd__or3b_1 A B C_N VGND VNB VPB VPWR X
.ends

* Black-box entry subcircuit for sky130_fd_sc_hd__nor2_4 abstract view
.subckt sky130_fd_sc_hd__nor2_4 A B VGND VNB VPB VPWR Y
.ends

* Black-box entry subcircuit for sky130_fd_sc_hd__xnor2_1 abstract view
.subckt sky130_fd_sc_hd__xnor2_1 A B VGND VNB VPB VPWR Y
.ends

* Black-box entry subcircuit for sky130_fd_sc_hd__o41a_1 abstract view
.subckt sky130_fd_sc_hd__o41a_1 A1 A2 A3 A4 B1 VGND VNB VPB VPWR X
.ends

* Black-box entry subcircuit for sky130_fd_sc_hd__o2111a_4 abstract view
.subckt sky130_fd_sc_hd__o2111a_4 A1 A2 B1 C1 D1 VGND VNB VPB VPWR X
.ends

* Black-box entry subcircuit for sky130_fd_sc_hd__a31o_4 abstract view
.subckt sky130_fd_sc_hd__a31o_4 A1 A2 A3 B1 VGND VNB VPB VPWR X
.ends

* Black-box entry subcircuit for sky130_fd_sc_hd__a221oi_1 abstract view
.subckt sky130_fd_sc_hd__a221oi_1 A1 A2 B1 B2 C1 VGND VNB VPB VPWR Y
.ends

* Black-box entry subcircuit for sky130_fd_sc_hd__a221oi_4 abstract view
.subckt sky130_fd_sc_hd__a221oi_4 A1 A2 B1 B2 C1 VGND VNB VPB VPWR Y
.ends

* Black-box entry subcircuit for sky130_fd_sc_hd__nand2_4 abstract view
.subckt sky130_fd_sc_hd__nand2_4 A B VGND VNB VPB VPWR Y
.ends

* Black-box entry subcircuit for sky130_fd_sc_hd__nand2_2 abstract view
.subckt sky130_fd_sc_hd__nand2_2 A B VGND VNB VPB VPWR Y
.ends

* Black-box entry subcircuit for sky130_fd_sc_hd__dlymetal6s2s_1 abstract view
.subckt sky130_fd_sc_hd__dlymetal6s2s_1 A VGND VNB VPB VPWR X
.ends

* Black-box entry subcircuit for sky130_fd_sc_hd__o22ai_1 abstract view
.subckt sky130_fd_sc_hd__o22ai_1 A1 A2 B1 B2 VGND VNB VPB VPWR Y
.ends

* Black-box entry subcircuit for sky130_fd_sc_hd__xnor2_2 abstract view
.subckt sky130_fd_sc_hd__xnor2_2 A B VGND VNB VPB VPWR Y
.ends

* Black-box entry subcircuit for sky130_fd_sc_hd__nor4b_1 abstract view
.subckt sky130_fd_sc_hd__nor4b_1 A B C D_N VGND VNB VPB VPWR Y
.ends

* Black-box entry subcircuit for sky130_fd_sc_hd__a22oi_4 abstract view
.subckt sky130_fd_sc_hd__a22oi_4 A1 A2 B1 B2 VGND VNB VPB VPWR Y
.ends

* Black-box entry subcircuit for sky130_fd_sc_hd__o22ai_2 abstract view
.subckt sky130_fd_sc_hd__o22ai_2 A1 A2 B1 B2 VGND VNB VPB VPWR Y
.ends

* Black-box entry subcircuit for sky130_fd_sc_hd__o21ba_1 abstract view
.subckt sky130_fd_sc_hd__o21ba_1 A1 A2 B1_N VGND VNB VPB VPWR X
.ends

* Black-box entry subcircuit for sky130_fd_sc_hd__or2_2 abstract view
.subckt sky130_fd_sc_hd__or2_2 A B VGND VNB VPB VPWR X
.ends

* Black-box entry subcircuit for sky130_fd_sc_hd__nor3_2 abstract view
.subckt sky130_fd_sc_hd__nor3_2 A B C VGND VNB VPB VPWR Y
.ends

* Black-box entry subcircuit for sky130_fd_sc_hd__o2bb2ai_2 abstract view
.subckt sky130_fd_sc_hd__o2bb2ai_2 A1_N A2_N B1 B2 VGND VNB VPB VPWR Y
.ends

* Black-box entry subcircuit for sky130_fd_sc_hd__o21a_2 abstract view
.subckt sky130_fd_sc_hd__o21a_2 A1 A2 B1 VGND VNB VPB VPWR X
.ends

* Black-box entry subcircuit for sky130_fd_sc_hd__a211oi_4 abstract view
.subckt sky130_fd_sc_hd__a211oi_4 A1 A2 B1 C1 VGND VNB VPB VPWR Y
.ends

* Black-box entry subcircuit for sky130_fd_sc_hd__o311ai_4 abstract view
.subckt sky130_fd_sc_hd__o311ai_4 A1 A2 A3 B1 C1 VGND VNB VPB VPWR Y
.ends

* Black-box entry subcircuit for sky130_fd_sc_hd__nor3b_1 abstract view
.subckt sky130_fd_sc_hd__nor3b_1 A B C_N VGND VNB VPB VPWR Y
.ends

* Black-box entry subcircuit for sky130_fd_sc_hd__or3b_4 abstract view
.subckt sky130_fd_sc_hd__or3b_4 A B C_N VGND VNB VPB VPWR X
.ends

* Black-box entry subcircuit for sky130_fd_sc_hd__a31oi_1 abstract view
.subckt sky130_fd_sc_hd__a31oi_1 A1 A2 A3 B1 VGND VNB VPB VPWR Y
.ends

* Black-box entry subcircuit for sky130_fd_sc_hd__and2b_1 abstract view
.subckt sky130_fd_sc_hd__and2b_1 A_N B VGND VNB VPB VPWR X
.ends

* Black-box entry subcircuit for sky130_fd_sc_hd__a21bo_1 abstract view
.subckt sky130_fd_sc_hd__a21bo_1 A1 A2 B1_N VGND VNB VPB VPWR X
.ends

* Black-box entry subcircuit for sky130_fd_sc_hd__a2bb2oi_4 abstract view
.subckt sky130_fd_sc_hd__a2bb2oi_4 A1_N A2_N B1 B2 VGND VNB VPB VPWR Y
.ends

* Black-box entry subcircuit for sky130_fd_sc_hd__a21o_2 abstract view
.subckt sky130_fd_sc_hd__a21o_2 A1 A2 B1 VGND VNB VPB VPWR X
.ends

* Black-box entry subcircuit for sky130_fd_sc_hd__o32a_2 abstract view
.subckt sky130_fd_sc_hd__o32a_2 A1 A2 A3 B1 B2 VGND VNB VPB VPWR X
.ends

* Black-box entry subcircuit for sky130_fd_sc_hd__and2_2 abstract view
.subckt sky130_fd_sc_hd__and2_2 A B VGND VNB VPB VPWR X
.ends

* Black-box entry subcircuit for sky130_fd_sc_hd__buf_8 abstract view
.subckt sky130_fd_sc_hd__buf_8 A VGND VNB VPB VPWR X
.ends

* Black-box entry subcircuit for sky130_fd_sc_hd__diode_2 abstract view
.subckt sky130_fd_sc_hd__diode_2 DIODE VGND VNB VPB VPWR
.ends

* Black-box entry subcircuit for sky130_fd_sc_hd__o311a_2 abstract view
.subckt sky130_fd_sc_hd__o311a_2 A1 A2 A3 B1 C1 VGND VNB VPB VPWR X
.ends

* Black-box entry subcircuit for sky130_fd_sc_hd__xor2_4 abstract view
.subckt sky130_fd_sc_hd__xor2_4 A B VGND VNB VPB VPWR X
.ends

* Black-box entry subcircuit for sky130_fd_sc_hd__and4b_2 abstract view
.subckt sky130_fd_sc_hd__and4b_2 A_N B C D VGND VNB VPB VPWR X
.ends

* Black-box entry subcircuit for sky130_fd_sc_hd__o2111ai_1 abstract view
.subckt sky130_fd_sc_hd__o2111ai_1 A1 A2 B1 C1 D1 VGND VNB VPB VPWR Y
.ends

* Black-box entry subcircuit for sky130_fd_sc_hd__a311oi_4 abstract view
.subckt sky130_fd_sc_hd__a311oi_4 A1 A2 A3 B1 C1 VGND VNB VPB VPWR Y
.ends

* Black-box entry subcircuit for sky130_fd_sc_hd__o21a_4 abstract view
.subckt sky130_fd_sc_hd__o21a_4 A1 A2 B1 VGND VNB VPB VPWR X
.ends

.subckt audio_soc_top audio_out clk gpio_pins[0] gpio_pins[1] gpio_pins[2] gpio_pins[3]
+ gpio_pins[4] gpio_pins[5] gpio_pins[6] gpio_pins[7] rst_n vccd1 vssd1
XTAP_177 vssd1 vccd1 sky130_fd_sc_hd__tapvpwrvgnd_1
XTAP_188 vssd1 vccd1 sky130_fd_sc_hd__tapvpwrvgnd_1
XTAP_199 vssd1 vccd1 sky130_fd_sc_hd__tapvpwrvgnd_1
X_3155_ u_audio.counter\[5\] _1563_ _1574_ _1575_ vssd1 vssd1 vccd1 vccd1 _1576_ sky130_fd_sc_hd__a22o_1
X_3086_ u_timer.count_reg\[14\] u_timer.count_reg\[13\] u_timer.count_reg\[12\] _1515_
+ vssd1 vssd1 vccd1 vccd1 _1525_ sky130_fd_sc_hd__and4_1
XFILLER_0_76_166 vccd1 vssd1 vccd1 vssd1 sky130_ef_sc_hd__decap_12
XFILLER_0_43_81 vssd1 vssd1 vccd1 vccd1 sky130_fd_sc_hd__fill_1
X_3988_ net310 vssd1 vssd1 vccd1 vccd1 _1990_ sky130_fd_sc_hd__clkbuf_1
X_2939_ _1351_ _1352_ _1353_ _1285_ vssd1 vssd1 vccd1 vccd1 _1397_ sky130_fd_sc_hd__a22o_1
X_4609_ clknet_leaf_40_clk _0410_ vssd1 vssd1 vccd1 vccd1 u_core.u_regfile.rf\[1\]\[11\]
+ sky130_fd_sc_hd__dfxtp_1
XFILLER_0_13_483 vssd1 vssd1 vccd1 vccd1 sky130_fd_sc_hd__fill_2
XFILLER_0_7_81 vssd1 vssd1 vccd1 vccd1 sky130_fd_sc_hd__decap_4
Xhold362 u_core.u_regfile.rf\[29\]\[18\] vssd1 vssd1 vccd1 vccd1 net395 sky130_fd_sc_hd__dlygate4sd3_1
Xhold340 u_core.u_regfile.rf\[29\]\[14\] vssd1 vssd1 vccd1 vccd1 net373 sky130_fd_sc_hd__dlygate4sd3_1
Xhold351 u_core.u_regfile.rf\[1\]\[27\] vssd1 vssd1 vccd1 vccd1 net384 sky130_fd_sc_hd__dlygate4sd3_1
Xhold384 u_core.u_regfile.rf\[4\]\[7\] vssd1 vssd1 vccd1 vccd1 net417 sky130_fd_sc_hd__dlygate4sd3_1
Xhold373 u_core.u_regfile.rf\[4\]\[3\] vssd1 vssd1 vccd1 vccd1 net406 sky130_fd_sc_hd__dlygate4sd3_1
Xhold395 u_core.u_regfile.rf\[29\]\[20\] vssd1 vssd1 vccd1 vccd1 net428 sky130_fd_sc_hd__dlygate4sd3_1
XFILLER_0_28_509 vssd1 vssd1 vccd1 vccd1 sky130_fd_sc_hd__fill_1
XFILLER_0_2_108 vssd1 vssd1 vccd1 vccd1 sky130_fd_sc_hd__decap_3
XFILLER_0_48_15 vccd1 vssd1 vccd1 vssd1 sky130_ef_sc_hd__decap_12
XFILLER_0_64_58 vssd1 vssd1 vccd1 vccd1 sky130_fd_sc_hd__fill_2
XFILLER_0_19_509 vssd1 vssd1 vccd1 vccd1 sky130_fd_sc_hd__fill_1
X_3911_ _1951_ vssd1 vssd1 vccd1 vccd1 _0418_ sky130_fd_sc_hd__clkbuf_1
XFILLER_0_46_328 vssd1 vssd1 vccd1 vccd1 sky130_fd_sc_hd__fill_2
XFILLER_0_58_177 vccd1 vssd1 vccd1 vssd1 sky130_ef_sc_hd__decap_12
X_3842_ net303 vssd1 vssd1 vccd1 vccd1 _1917_ sky130_fd_sc_hd__clkbuf_1
XFILLER_0_39_391 vssd1 vssd1 vccd1 vccd1 sky130_fd_sc_hd__fill_1
X_3773_ _1464_ _1465_ _1875_ _1882_ vssd1 vssd1 vccd1 vccd1 _0349_ sky130_fd_sc_hd__a31o_1
X_2724_ _0881_ _0939_ u_core.u_regfile.rf\[4\]\[18\] vssd1 vssd1 vccd1 vccd1 _1182_
+ sky130_fd_sc_hd__a21oi_1
X_2655_ _0776_ _0697_ _1106_ _1112_ vssd1 vssd1 vccd1 vccd1 _1113_ sky130_fd_sc_hd__nor4_2
X_2586_ _1042_ _0769_ _1043_ vssd1 vssd1 vccd1 vccd1 _1044_ sky130_fd_sc_hd__a21oi_1
X_4325_ clknet_leaf_2_clk _0136_ vssd1 vssd1 vccd1 vccd1 u_core.u_regfile.rf\[4\]\[25\]
+ sky130_fd_sc_hd__dfxtp_1
XFILLER_0_10_475 vssd1 vssd1 vccd1 vccd1 sky130_fd_sc_hd__fill_1
XFILLER_0_1_196 vccd1 vssd1 vccd1 vssd1 sky130_ef_sc_hd__decap_12
XFILLER_0_10_497 vssd1 vssd1 vccd1 vccd1 sky130_fd_sc_hd__fill_2
X_4256_ clknet_leaf_27_clk _0071_ vssd1 vssd1 vccd1 vccd1 u_core.u_regfile.rf\[31\]\[24\]
+ sky130_fd_sc_hd__dfxtp_2
X_3207_ net482 vssd1 vssd1 vccd1 vccd1 _1605_ sky130_fd_sc_hd__clkbuf_1
X_4187_ _2093_ vssd1 vssd1 vccd1 vccd1 _0552_ sky130_fd_sc_hd__clkbuf_1
X_3138_ _1559_ _0684_ _1560_ vssd1 vssd1 vccd1 vccd1 _1561_ sky130_fd_sc_hd__and3b_1
XFILLER_0_69_409 vssd1 vssd1 vccd1 vccd1 sky130_fd_sc_hd__fill_1
X_3069_ u_timer.count_reg\[9\] u_timer.count_reg\[8\] _1505_ u_timer.count_reg\[10\]
+ vssd1 vssd1 vccd1 vccd1 _1512_ sky130_fd_sc_hd__a31o_1
XFILLER_0_9_241 vssd1 vssd1 vccd1 vccd1 sky130_fd_sc_hd__fill_2
XFILLER_0_64_147 vssd1 vssd1 vccd1 vccd1 sky130_fd_sc_hd__fill_1
XFILLER_0_9_296 vssd1 vssd1 vccd1 vccd1 sky130_fd_sc_hd__decap_4
XFILLER_0_60_397 vssd1 vssd1 vccd1 vccd1 sky130_fd_sc_hd__decap_8
Xhold170 u_core.u_regfile.rf\[3\]\[26\] vssd1 vssd1 vccd1 vccd1 net203 sky130_fd_sc_hd__dlygate4sd3_1
Xhold181 u_core.u_regfile.rf\[25\]\[17\] vssd1 vssd1 vccd1 vccd1 net214 sky130_fd_sc_hd__dlygate4sd3_1
Xhold192 u_core.u_regfile.rf\[2\]\[10\] vssd1 vssd1 vccd1 vccd1 net225 sky130_fd_sc_hd__dlygate4sd3_1
XFILLER_0_68_475 vssd1 vssd1 vccd1 vccd1 sky130_fd_sc_hd__fill_1
XFILLER_0_50_27 vssd1 vssd1 vccd1 vccd1 sky130_fd_sc_hd__fill_1
XFILLER_0_3_417 vccd1 vssd1 vccd1 vssd1 sky130_ef_sc_hd__decap_12
XFILLER_0_70_139 vssd1 vssd1 vccd1 vccd1 sky130_fd_sc_hd__fill_1
X_2440_ _0897_ vssd1 vssd1 vccd1 vccd1 _0898_ sky130_fd_sc_hd__clkbuf_4
X_2371_ u_core.u_regfile.rf\[28\]\[25\] _0697_ _0701_ _0703_ _0828_ vssd1 vssd1 vccd1
+ vccd1 _0829_ sky130_fd_sc_hd__a221o_1
X_4110_ net379 vssd1 vssd1 vccd1 vccd1 _2051_ sky130_fd_sc_hd__clkbuf_1
XFILLER_0_75_57 vccd1 vssd1 vccd1 vssd1 sky130_ef_sc_hd__decap_12
X_4041_ _2016_ vssd1 vssd1 vccd1 vccd1 _0483_ sky130_fd_sc_hd__clkbuf_1
XFILLER_0_46_114 vssd1 vssd1 vccd1 vccd1 sky130_fd_sc_hd__fill_2
XFILLER_0_74_489 vccd1 vssd1 vccd1 vssd1 sky130_ef_sc_hd__decap_12
XFILLER_0_34_309 vssd1 vssd1 vccd1 vccd1 sky130_fd_sc_hd__decap_6
X_3825_ _1908_ vssd1 vssd1 vccd1 vccd1 _0375_ sky130_fd_sc_hd__clkbuf_1
X_3756_ _1872_ vssd1 vssd1 vccd1 vccd1 _0342_ sky130_fd_sc_hd__clkbuf_1
XFILLER_0_40_71 vssd1 vssd1 vccd1 vccd1 sky130_fd_sc_hd__decap_3
XFILLER_0_42_342 vssd1 vssd1 vccd1 vccd1 sky130_fd_sc_hd__decap_3
X_2707_ u_core.u_regfile.rf\[31\]\[19\] _0727_ _0739_ _1164_ _1162_ vssd1 vssd1 vccd1
+ vccd1 _1165_ sky130_fd_sc_hd__o2111ai_4
XFILLER_0_71_3 vccd1 vssd1 vccd1 vssd1 sky130_ef_sc_hd__decap_12
X_3687_ net170 vssd1 vssd1 vccd1 vccd1 _1836_ sky130_fd_sc_hd__clkbuf_1
X_2638_ _0685_ u_core.u_regfile.rf\[29\]\[4\] _1095_ vssd1 vssd1 vccd1 vccd1 _1096_
+ sky130_fd_sc_hd__a21oi_1
X_2569_ u_core.u_regfile.rf\[1\]\[0\] _0742_ _0731_ _0709_ vssd1 vssd1 vccd1 vccd1
+ _1027_ sky130_fd_sc_hd__o2bb2a_1
X_4308_ clknet_leaf_46_clk _0119_ vssd1 vssd1 vccd1 vccd1 u_core.u_regfile.rf\[4\]\[8\]
+ sky130_fd_sc_hd__dfxtp_1
X_4239_ clknet_leaf_6_clk _0054_ vssd1 vssd1 vccd1 vccd1 u_core.u_regfile.rf\[31\]\[7\]
+ sky130_fd_sc_hd__dfxtp_1
XFILLER_0_29_28 vssd1 vssd1 vccd1 vccd1 sky130_fd_sc_hd__decap_4
XFILLER_0_45_27 vssd1 vssd1 vccd1 vccd1 sky130_fd_sc_hd__decap_4
XFILLER_0_0_29 vccd1 vssd1 vccd1 vssd1 sky130_ef_sc_hd__decap_12
XFILLER_0_61_15 vccd1 vssd1 vccd1 vssd1 sky130_ef_sc_hd__decap_12
XFILLER_0_71_404 vssd1 vssd1 vccd1 vccd1 sky130_fd_sc_hd__fill_2
XFILLER_0_9_27 vccd1 vssd1 vccd1 vssd1 sky130_ef_sc_hd__decap_12
X_4590_ clknet_leaf_34_clk _0391_ vssd1 vssd1 vccd1 vccd1 u_core.u_regfile.rf\[27\]\[24\]
+ sky130_fd_sc_hd__dfxtp_1
XFILLER_0_43_139 vssd1 vssd1 vccd1 vccd1 sky130_fd_sc_hd__decap_3
X_3610_ _1797_ vssd1 vssd1 vccd1 vccd1 _0271_ sky130_fd_sc_hd__clkbuf_1
XFILLER_0_3_214 vssd1 vssd1 vccd1 vccd1 sky130_fd_sc_hd__decap_8
XFILLER_0_3_225 vssd1 vssd1 vccd1 vccd1 sky130_fd_sc_hd__decap_6
X_3541_ _1775_ vssd1 vssd1 vccd1 vccd1 _0224_ sky130_fd_sc_hd__clkbuf_1
XFILLER_0_24_342 vssd1 vssd1 vccd1 vccd1 sky130_fd_sc_hd__fill_1
XFILLER_0_10_41 vssd1 vssd1 vccd1 vccd1 sky130_fd_sc_hd__decap_6
XFILLER_0_3_269 vssd1 vssd1 vccd1 vccd1 sky130_fd_sc_hd__decap_8
X_3472_ _1737_ _1715_ _1706_ _1185_ vssd1 vssd1 vccd1 vccd1 _1738_ sky130_fd_sc_hd__nand4_1
X_2423_ _0699_ vssd1 vssd1 vccd1 vccd1 _0881_ sky130_fd_sc_hd__clkbuf_8
X_2354_ _0721_ _0729_ _0811_ vssd1 vssd1 vccd1 vccd1 _0812_ sky130_fd_sc_hd__o21ai_4
X_2285_ _0742_ vssd1 vssd1 vccd1 vccd1 _0743_ sky130_fd_sc_hd__buf_4
X_4024_ net175 vssd1 vssd1 vccd1 vccd1 _2008_ sky130_fd_sc_hd__clkbuf_1
XFILLER_0_74_264 vssd1 vssd1 vccd1 vccd1 sky130_fd_sc_hd__decap_8
XFILLER_0_74_253 vssd1 vssd1 vccd1 vccd1 sky130_fd_sc_hd__decap_3
XFILLER_0_34_106 vssd1 vssd1 vccd1 vccd1 sky130_fd_sc_hd__fill_1
XFILLER_0_62_415 vssd1 vssd1 vccd1 vccd1 sky130_fd_sc_hd__decap_4
XFILLER_0_34_139 vssd1 vssd1 vccd1 vccd1 sky130_fd_sc_hd__fill_1
X_3808_ net286 vssd1 vssd1 vccd1 vccd1 _1900_ sky130_fd_sc_hd__clkbuf_1
X_4788_ clknet_leaf_37_clk _0556_ vssd1 vssd1 vccd1 vccd1 u_core.u_regfile.rf\[3\]\[21\]
+ sky130_fd_sc_hd__dfxtp_1
XFILLER_0_15_364 vssd1 vssd1 vccd1 vccd1 sky130_fd_sc_hd__fill_1
X_3739_ _1674_ _1862_ net37 vssd1 vssd1 vccd1 vccd1 _1863_ sky130_fd_sc_hd__o21ai_1
XFILLER_0_42_161 vssd1 vssd1 vccd1 vccd1 sky130_fd_sc_hd__decap_4
XFILLER_0_70_470 vssd1 vssd1 vccd1 vccd1 sky130_fd_sc_hd__decap_6
XFILLER_0_53_404 vssd1 vssd1 vccd1 vccd1 sky130_fd_sc_hd__fill_2
XFILLER_0_61_492 vssd1 vssd1 vccd1 vccd1 sky130_fd_sc_hd__fill_1
XTAP_507 vssd1 vccd1 sky130_fd_sc_hd__tapvpwrvgnd_1
XTAP_518 vssd1 vccd1 sky130_fd_sc_hd__tapvpwrvgnd_1
XTAP_529 vssd1 vccd1 sky130_fd_sc_hd__tapvpwrvgnd_1
XFILLER_0_56_15 vccd1 vssd1 vccd1 vssd1 sky130_ef_sc_hd__decap_12
X_2972_ _0736_ _1146_ _1033_ _1028_ _1429_ vssd1 vssd1 vccd1 vccd1 _1430_ sky130_fd_sc_hd__a41o_1
X_4711_ clknet_leaf_40_clk _0512_ vssd1 vssd1 vccd1 vccd1 u_core.u_regfile.rf\[25\]\[17\]
+ sky130_fd_sc_hd__dfxtp_1
XFILLER_0_44_415 vssd1 vssd1 vccd1 vccd1 sky130_fd_sc_hd__decap_4
XFILLER_0_56_253 vssd1 vssd1 vccd1 vccd1 sky130_fd_sc_hd__decap_3
X_4642_ clknet_leaf_39_clk _0443_ vssd1 vssd1 vccd1 vccd1 u_core.u_regfile.rf\[26\]\[12\]
+ sky130_fd_sc_hd__dfxtp_1
XFILLER_0_4_501 vssd1 vssd1 vccd1 vccd1 sky130_fd_sc_hd__decap_8
XFILLER_0_21_73 vccd1 vssd1 vccd1 vssd1 sky130_ef_sc_hd__decap_12
X_4573_ clknet_leaf_36_clk _0374_ vssd1 vssd1 vccd1 vccd1 u_core.u_regfile.rf\[27\]\[7\]
+ sky130_fd_sc_hd__dfxtp_1
X_3524_ net372 vssd1 vssd1 vccd1 vccd1 _1767_ sky130_fd_sc_hd__clkbuf_1
X_3455_ _1479_ vssd1 vssd1 vccd1 vccd1 _1726_ sky130_fd_sc_hd__buf_2
X_2406_ _0862_ _0863_ _0750_ vssd1 vssd1 vccd1 vccd1 _0864_ sky130_fd_sc_hd__nand3_1
X_3386_ _1671_ _1672_ _1673_ net57 vssd1 vssd1 vccd1 vccd1 _0171_ sky130_fd_sc_hd__o31a_1
XFILLER_0_34_3 vssd1 vssd1 vccd1 vccd1 sky130_fd_sc_hd__decap_4
X_2337_ _0754_ _0714_ u_core.u_regfile.rf\[6\]\[27\] vssd1 vssd1 vccd1 vccd1 _0795_
+ sky130_fd_sc_hd__a21o_1
X_2268_ _0725_ vssd1 vssd1 vccd1 vccd1 _0726_ sky130_fd_sc_hd__clkbuf_4
X_4007_ _1999_ vssd1 vssd1 vccd1 vccd1 _0466_ sky130_fd_sc_hd__clkbuf_1
X_2199_ _0631_ _0657_ _0626_ vssd1 vssd1 vccd1 vccd1 _0658_ sky130_fd_sc_hd__a21oi_1
XFILLER_0_35_415 vssd1 vssd1 vccd1 vccd1 sky130_fd_sc_hd__decap_4
XFILLER_0_47_297 vccd1 vssd1 vccd1 vssd1 sky130_ef_sc_hd__decap_12
XFILLER_0_7_361 vccd1 vssd1 vccd1 vssd1 sky130_ef_sc_hd__decap_12
Xhold30 u_core.u_regfile.rf\[7\]\[30\] vssd1 vssd1 vccd1 vccd1 net63 sky130_fd_sc_hd__dlygate4sd3_1
Xhold41 u_core.u_regfile.rf\[28\]\[1\] vssd1 vssd1 vccd1 vccd1 net74 sky130_fd_sc_hd__dlygate4sd3_1
Xhold63 u_core.u_regfile.rf\[7\]\[22\] vssd1 vssd1 vccd1 vccd1 net96 sky130_fd_sc_hd__dlygate4sd3_1
Xhold74 u_core.u_regfile.rf\[6\]\[26\] vssd1 vssd1 vccd1 vccd1 net107 sky130_fd_sc_hd__dlygate4sd3_1
Xhold52 u_core.u_regfile.rf\[5\]\[18\] vssd1 vssd1 vccd1 vccd1 net85 sky130_fd_sc_hd__dlygate4sd3_1
Xhold85 u_core.u_regfile.rf\[6\]\[5\] vssd1 vssd1 vccd1 vccd1 net118 sky130_fd_sc_hd__dlygate4sd3_1
Xhold96 u_core.u_regfile.rf\[7\]\[6\] vssd1 vssd1 vccd1 vccd1 net129 sky130_fd_sc_hd__dlygate4sd3_1
XFILLER_0_85_337 vccd1 vssd1 vccd1 vssd1 sky130_ef_sc_hd__decap_12
XFILLER_0_26_448 vssd1 vssd1 vccd1 vccd1 sky130_fd_sc_hd__fill_1
XFILLER_0_41_429 vssd1 vssd1 vccd1 vccd1 sky130_fd_sc_hd__fill_1
XTAP_315 vssd1 vccd1 sky130_fd_sc_hd__tapvpwrvgnd_1
XTAP_304 vssd1 vccd1 sky130_fd_sc_hd__tapvpwrvgnd_1
XFILLER_0_21_175 vssd1 vssd1 vccd1 vccd1 sky130_fd_sc_hd__fill_2
XTAP_337 vssd1 vccd1 sky130_fd_sc_hd__tapvpwrvgnd_1
XTAP_326 vssd1 vccd1 sky130_fd_sc_hd__tapvpwrvgnd_1
XTAP_348 vssd1 vccd1 sky130_fd_sc_hd__tapvpwrvgnd_1
X_3240_ _1621_ vssd1 vssd1 vccd1 vccd1 _0077_ sky130_fd_sc_hd__clkbuf_1
XTAP_359 vssd1 vccd1 sky130_fd_sc_hd__tapvpwrvgnd_1
X_3171_ net415 _1585_ vssd1 vssd1 vccd1 vccd1 _0043_ sky130_fd_sc_hd__xor2_1
X_2122_ _0579_ u_timer.threshold_reg\[29\] _0578_ _0580_ vssd1 vssd1 vccd1 vccd1 _0581_
+ sky130_fd_sc_hd__a211o_1
XFILLER_0_83_57 vccd1 vssd1 vccd1 vssd1 sky130_ef_sc_hd__decap_12
XFILLER_0_16_51 vssd1 vssd1 vccd1 vccd1 sky130_fd_sc_hd__fill_2
XFILLER_0_76_304 vssd1 vssd1 vccd1 vccd1 sky130_fd_sc_hd__decap_4
XFILLER_0_32_83 vssd1 vssd1 vccd1 vccd1 sky130_fd_sc_hd__fill_1
X_2955_ _1412_ vssd1 vssd1 vccd1 vccd1 _1413_ sky130_fd_sc_hd__clkbuf_4
X_2886_ _1339_ _1343_ _1271_ vssd1 vssd1 vccd1 vccd1 _1344_ sky130_fd_sc_hd__o21ai_2
XFILLER_0_32_418 vssd1 vssd1 vccd1 vccd1 sky130_fd_sc_hd__fill_2
X_4625_ clknet_leaf_9_clk _0426_ vssd1 vssd1 vccd1 vccd1 u_core.u_regfile.rf\[1\]\[27\]
+ sky130_fd_sc_hd__dfxtp_1
Xhold500 u_timer.count_reg\[8\] vssd1 vssd1 vccd1 vccd1 net533 sky130_fd_sc_hd__dlygate4sd3_1
XFILLER_0_4_353 vssd1 vssd1 vccd1 vccd1 sky130_fd_sc_hd__fill_1
XFILLER_0_4_375 vssd1 vssd1 vccd1 vccd1 sky130_fd_sc_hd__fill_1
X_4556_ clknet_leaf_19_clk _0357_ vssd1 vssd1 vccd1 vccd1 u_core.u_regfile.rf\[28\]\[22\]
+ sky130_fd_sc_hd__dfxtp_1
Xhold511 u_timer.threshold_reg\[12\] vssd1 vssd1 vccd1 vccd1 net544 sky130_fd_sc_hd__dlygate4sd3_1
X_3507_ _1758_ vssd1 vssd1 vccd1 vccd1 _0207_ sky130_fd_sc_hd__clkbuf_1
XFILLER_0_40_451 vssd1 vssd1 vccd1 vccd1 sky130_fd_sc_hd__decap_4
Xhold522 u_core.u_regfile.rf\[28\]\[15\] vssd1 vssd1 vccd1 vccd1 net555 sky130_fd_sc_hd__dlygate4sd3_1
XFILLER_0_12_197 vssd1 vssd1 vccd1 vccd1 sky130_fd_sc_hd__fill_2
X_4487_ clknet_leaf_33_clk _0288_ vssd1 vssd1 vccd1 vccd1 u_core.u_regfile.rf\[30\]\[17\]
+ sky130_fd_sc_hd__dfxtp_1
X_3438_ _1713_ vssd1 vssd1 vccd1 vccd1 _1714_ sky130_fd_sc_hd__buf_2
XTAP_871 vssd1 vccd1 sky130_fd_sc_hd__tapvpwrvgnd_1
XTAP_860 vssd1 vccd1 sky130_fd_sc_hd__tapvpwrvgnd_1
X_3369_ _1668_ _1669_ _1670_ net366 vssd1 vssd1 vccd1 vccd1 _0157_ sky130_fd_sc_hd__o31a_1
XTAP_893 vssd1 vccd1 sky130_fd_sc_hd__tapvpwrvgnd_1
XTAP_882 vssd1 vccd1 sky130_fd_sc_hd__tapvpwrvgnd_1
XFILLER_0_79_175 vssd1 vssd1 vccd1 vccd1 sky130_fd_sc_hd__fill_1
XFILLER_0_79_186 vssd1 vssd1 vccd1 vccd1 sky130_fd_sc_hd__fill_1
Xoutput7 net7 vssd1 vssd1 vccd1 vccd1 gpio_pins[4] sky130_fd_sc_hd__buf_2
XFILLER_0_53_27 vccd1 vssd1 vccd1 vssd1 sky130_ef_sc_hd__decap_12
XPHY_170 vssd1 vssd1 vccd1 vccd1 sky130_fd_sc_hd__decap_3
XFILLER_0_73_329 vssd1 vssd1 vccd1 vccd1 sky130_fd_sc_hd__fill_2
XFILLER_0_81_340 vccd1 vssd1 vccd1 vssd1 sky130_ef_sc_hd__decap_12
X_2740_ _0812_ _1195_ _1196_ _1197_ vssd1 vssd1 vccd1 vccd1 _1198_ sky130_fd_sc_hd__a31o_2
X_2671_ _1127_ _1128_ vssd1 vssd1 vccd1 vccd1 _1129_ sky130_fd_sc_hd__nand2_1
X_4410_ clknet_leaf_44_clk _0221_ vssd1 vssd1 vccd1 vccd1 u_core.u_regfile.rf\[29\]\[14\]
+ sky130_fd_sc_hd__dfxtp_1
X_4341_ clknet_leaf_44_clk _0152_ vssd1 vssd1 vccd1 vccd1 u_core.u_regfile.rf\[5\]\[9\]
+ sky130_fd_sc_hd__dfxtp_1
X_4272_ clknet_leaf_49_clk _0083_ vssd1 vssd1 vccd1 vccd1 u_core.u_regfile.rf\[6\]\[4\]
+ sky130_fd_sc_hd__dfxtp_1
X_3223_ net545 vssd1 vssd1 vccd1 vccd1 _1613_ sky130_fd_sc_hd__clkbuf_1
XTAP_178 vssd1 vccd1 sky130_fd_sc_hd__tapvpwrvgnd_1
XTAP_189 vssd1 vccd1 sky130_fd_sc_hd__tapvpwrvgnd_1
X_3154_ u_audio.counter\[4\] _1564_ vssd1 vssd1 vccd1 vccd1 _1575_ sky130_fd_sc_hd__or2_1
X_3085_ _1524_ vssd1 vssd1 vccd1 vccd1 _0011_ sky130_fd_sc_hd__clkbuf_1
XFILLER_0_49_337 vssd1 vssd1 vccd1 vccd1 sky130_fd_sc_hd__decap_8
XFILLER_0_76_178 vssd1 vssd1 vccd1 vccd1 sky130_fd_sc_hd__fill_2
X_3987_ _1989_ vssd1 vssd1 vccd1 vccd1 _0456_ sky130_fd_sc_hd__clkbuf_1
X_2938_ _1206_ _1207_ _1395_ vssd1 vssd1 vccd1 vccd1 _1396_ sky130_fd_sc_hd__o21ai_2
XFILLER_0_17_267 vssd1 vssd1 vccd1 vccd1 sky130_fd_sc_hd__decap_4
XFILLER_0_32_248 vssd1 vssd1 vccd1 vccd1 sky130_fd_sc_hd__fill_1
X_2869_ _1325_ _1320_ _0736_ _0724_ vssd1 vssd1 vccd1 vccd1 _1327_ sky130_fd_sc_hd__and4b_1
X_4608_ clknet_leaf_40_clk _0409_ vssd1 vssd1 vccd1 vccd1 u_core.u_regfile.rf\[1\]\[10\]
+ sky130_fd_sc_hd__dfxtp_1
X_4539_ clknet_leaf_6_clk _0340_ vssd1 vssd1 vccd1 vccd1 u_core.u_regfile.rf\[28\]\[5\]
+ sky130_fd_sc_hd__dfxtp_1
Xhold341 u_core.u_regfile.rf\[5\]\[21\] vssd1 vssd1 vccd1 vccd1 net374 sky130_fd_sc_hd__dlygate4sd3_1
Xhold352 u_core.u_regfile.rf\[29\]\[28\] vssd1 vssd1 vccd1 vccd1 net385 sky130_fd_sc_hd__dlygate4sd3_1
Xhold330 u_core.u_regfile.rf\[24\]\[2\] vssd1 vssd1 vccd1 vccd1 net363 sky130_fd_sc_hd__dlygate4sd3_1
Xhold363 u_core.u_regfile.rf\[1\]\[22\] vssd1 vssd1 vccd1 vccd1 net396 sky130_fd_sc_hd__dlygate4sd3_1
Xhold385 u_core.u_regfile.rf\[4\]\[0\] vssd1 vssd1 vccd1 vccd1 net418 sky130_fd_sc_hd__dlygate4sd3_1
Xhold396 u_core.u_regfile.rf\[4\]\[30\] vssd1 vssd1 vccd1 vccd1 net429 sky130_fd_sc_hd__dlygate4sd3_1
Xhold374 u_core.u_regfile.rf\[29\]\[1\] vssd1 vssd1 vccd1 vccd1 net407 sky130_fd_sc_hd__dlygate4sd3_1
XTAP_690 vssd1 vccd1 sky130_fd_sc_hd__tapvpwrvgnd_1
XFILLER_0_31_281 vssd1 vssd1 vccd1 vccd1 sky130_fd_sc_hd__fill_2
XFILLER_0_48_27 vssd1 vssd1 vccd1 vccd1 sky130_fd_sc_hd__fill_1
XFILLER_0_64_15 vccd1 vssd1 vccd1 vssd1 sky130_ef_sc_hd__decap_12
XFILLER_0_58_123 vssd1 vssd1 vccd1 vccd1 sky130_fd_sc_hd__decap_4
X_3910_ net511 vssd1 vssd1 vccd1 vccd1 _1951_ sky130_fd_sc_hd__clkbuf_1
X_3841_ _1916_ vssd1 vssd1 vccd1 vccd1 _0383_ sky130_fd_sc_hd__clkbuf_1
XFILLER_0_39_370 vssd1 vssd1 vccd1 vccd1 sky130_fd_sc_hd__decap_4
XFILLER_0_58_189 vssd1 vssd1 vccd1 vccd1 sky130_fd_sc_hd__decap_6
XFILLER_0_13_52 vssd1 vssd1 vccd1 vccd1 sky130_fd_sc_hd__decap_4
XFILLER_0_6_404 vssd1 vssd1 vccd1 vccd1 sky130_fd_sc_hd__fill_1
X_3772_ _1876_ _1877_ net512 vssd1 vssd1 vccd1 vccd1 _1882_ sky130_fd_sc_hd__o21a_1
X_2723_ _0938_ u_core.u_regfile.rf\[7\]\[18\] _0939_ vssd1 vssd1 vccd1 vccd1 _1181_
+ sky130_fd_sc_hd__nand3_1
X_2654_ _1107_ _1111_ vssd1 vssd1 vccd1 vccd1 _1112_ sky130_fd_sc_hd__nor2_2
X_2585_ _0730_ _0740_ u_core.u_regfile.rf\[28\]\[1\] vssd1 vssd1 vccd1 vccd1 _1043_
+ sky130_fd_sc_hd__o21a_1
XFILLER_0_22_281 vssd1 vssd1 vccd1 vccd1 sky130_fd_sc_hd__fill_2
X_4324_ clknet_leaf_2_clk _0135_ vssd1 vssd1 vccd1 vccd1 u_core.u_regfile.rf\[4\]\[24\]
+ sky130_fd_sc_hd__dfxtp_1
X_4255_ clknet_leaf_28_clk _0070_ vssd1 vssd1 vccd1 vccd1 u_core.u_regfile.rf\[31\]\[23\]
+ sky130_fd_sc_hd__dfxtp_1
X_4186_ net216 vssd1 vssd1 vccd1 vccd1 _2093_ sky130_fd_sc_hd__clkbuf_1
X_3206_ _1604_ vssd1 vssd1 vccd1 vccd1 _0060_ sky130_fd_sc_hd__clkbuf_1
X_3137_ u_timer.count_reg\[29\] u_timer.count_reg\[28\] _1552_ u_timer.count_reg\[30\]
+ vssd1 vssd1 vccd1 vccd1 _1560_ sky130_fd_sc_hd__a31o_1
X_3068_ _1511_ vssd1 vssd1 vccd1 vccd1 _0038_ sky130_fd_sc_hd__clkbuf_1
XFILLER_0_77_443 vssd1 vssd1 vccd1 vccd1 sky130_fd_sc_hd__fill_1
XFILLER_0_5_470 vssd1 vssd1 vccd1 vccd1 sky130_fd_sc_hd__decap_8
Xhold171 u_core.u_regfile.rf\[2\]\[3\] vssd1 vssd1 vccd1 vccd1 net204 sky130_fd_sc_hd__dlygate4sd3_1
Xhold160 u_core.u_regfile.rf\[30\]\[3\] vssd1 vssd1 vccd1 vccd1 net193 sky130_fd_sc_hd__dlygate4sd3_1
Xhold182 u_core.u_regfile.rf\[27\]\[23\] vssd1 vssd1 vccd1 vccd1 net215 sky130_fd_sc_hd__dlygate4sd3_1
Xhold193 u_core.u_regfile.rf\[30\]\[25\] vssd1 vssd1 vccd1 vccd1 net226 sky130_fd_sc_hd__dlygate4sd3_1
XFILLER_0_34_29 vssd1 vssd1 vccd1 vccd1 sky130_fd_sc_hd__fill_1
XFILLER_0_68_421 vssd1 vssd1 vccd1 vccd1 sky130_fd_sc_hd__fill_1
XFILLER_0_28_307 vssd1 vssd1 vccd1 vccd1 sky130_fd_sc_hd__fill_1
XFILLER_0_3_429 vccd1 vssd1 vccd1 vssd1 sky130_ef_sc_hd__decap_12
XFILLER_0_59_15 vccd1 vssd1 vccd1 vssd1 sky130_ef_sc_hd__decap_12
X_2370_ _0827_ _0710_ _0803_ vssd1 vssd1 vccd1 vccd1 _0828_ sky130_fd_sc_hd__and3_1
XFILLER_0_75_69 vccd1 vssd1 vccd1 vssd1 sky130_ef_sc_hd__decap_12
X_4040_ net159 vssd1 vssd1 vccd1 vccd1 _2016_ sky130_fd_sc_hd__clkbuf_1
XFILLER_0_78_229 vssd1 vssd1 vccd1 vccd1 sky130_fd_sc_hd__fill_2
XFILLER_0_24_51 vssd1 vssd1 vccd1 vccd1 sky130_fd_sc_hd__decap_6
X_3824_ net201 vssd1 vssd1 vccd1 vccd1 _1908_ sky130_fd_sc_hd__clkbuf_1
X_3755_ _1443_ net506 _1868_ vssd1 vssd1 vccd1 vccd1 _1872_ sky130_fd_sc_hd__mux2_1
XFILLER_0_42_321 vssd1 vssd1 vccd1 vccd1 sky130_fd_sc_hd__fill_1
XFILLER_0_40_94 vssd1 vssd1 vccd1 vccd1 sky130_fd_sc_hd__decap_4
X_2706_ _0876_ _0878_ _1153_ _1157_ vssd1 vssd1 vccd1 vccd1 _1164_ sky130_fd_sc_hd__o22a_1
X_3686_ _1835_ vssd1 vssd1 vccd1 vccd1 _0309_ sky130_fd_sc_hd__clkbuf_1
X_2637_ _0721_ u_core.u_regfile.rf\[31\]\[4\] vssd1 vssd1 vccd1 vccd1 _1095_ sky130_fd_sc_hd__and2_1
XFILLER_0_64_3 vccd1 vssd1 vccd1 vssd1 sky130_ef_sc_hd__decap_12
X_2568_ _1024_ _1025_ _0755_ vssd1 vssd1 vccd1 vccd1 _1026_ sky130_fd_sc_hd__a21oi_2
X_4307_ clknet_leaf_46_clk _0118_ vssd1 vssd1 vccd1 vccd1 u_core.u_regfile.rf\[4\]\[7\]
+ sky130_fd_sc_hd__dfxtp_1
X_2499_ u_core.u_regfile.rf\[5\]\[8\] _0879_ _0773_ _0952_ _0956_ vssd1 vssd1 vccd1
+ vccd1 _0957_ sky130_fd_sc_hd__o221ai_4
X_4238_ clknet_leaf_8_clk _0053_ vssd1 vssd1 vccd1 vccd1 u_core.u_regfile.rf\[31\]\[6\]
+ sky130_fd_sc_hd__dfxtp_1
X_4169_ _2084_ vssd1 vssd1 vccd1 vccd1 _0543_ sky130_fd_sc_hd__clkbuf_1
XFILLER_0_65_446 vssd1 vssd1 vccd1 vccd1 sky130_fd_sc_hd__fill_2
XFILLER_0_18_362 vssd1 vssd1 vccd1 vccd1 sky130_fd_sc_hd__fill_2
XFILLER_0_52_107 vssd1 vssd1 vccd1 vccd1 sky130_fd_sc_hd__fill_2
XFILLER_0_18_373 vccd1 vssd1 vccd1 vssd1 sky130_ef_sc_hd__decap_12
XFILLER_0_33_321 vssd1 vssd1 vccd1 vccd1 sky130_fd_sc_hd__decap_3
XFILLER_0_45_181 vssd1 vssd1 vccd1 vccd1 sky130_fd_sc_hd__decap_4
XFILLER_0_21_505 vssd1 vssd1 vccd1 vccd1 sky130_fd_sc_hd__decap_4
XFILLER_0_33_343 vssd1 vssd1 vccd1 vccd1 sky130_fd_sc_hd__decap_4
XFILLER_0_45_192 vssd1 vssd1 vccd1 vccd1 sky130_fd_sc_hd__decap_8
XFILLER_0_60_195 vssd1 vssd1 vccd1 vccd1 sky130_fd_sc_hd__fill_1
XFILLER_0_28_115 vccd1 vssd1 vccd1 vssd1 sky130_ef_sc_hd__decap_12
XFILLER_0_68_251 vssd1 vssd1 vccd1 vccd1 sky130_fd_sc_hd__fill_1
XFILLER_0_68_273 vssd1 vssd1 vccd1 vccd1 sky130_fd_sc_hd__fill_2
XFILLER_0_71_449 vssd1 vssd1 vccd1 vccd1 sky130_fd_sc_hd__decap_8
XFILLER_0_9_39 vccd1 vssd1 vccd1 vssd1 sky130_ef_sc_hd__decap_12
X_3540_ net383 vssd1 vssd1 vccd1 vccd1 _1775_ sky130_fd_sc_hd__clkbuf_1
X_3471_ _1332_ vssd1 vssd1 vccd1 vccd1 _1737_ sky130_fd_sc_hd__clkbuf_4
X_2422_ u_core.u_regfile.rf\[29\]\[12\] u_core.u_regfile.rf\[31\]\[12\] _0704_ vssd1
+ vssd1 vccd1 vccd1 _0880_ sky130_fd_sc_hd__mux2_1
X_2353_ _0687_ u_imem.addr\[4\] u_imem.addr\[3\] vssd1 vssd1 vccd1 vccd1 _0811_ sky130_fd_sc_hd__o21bai_2
X_2284_ _0704_ _0730_ _0695_ _0737_ vssd1 vssd1 vccd1 vccd1 _0742_ sky130_fd_sc_hd__o22a_4
X_4023_ _2007_ vssd1 vssd1 vccd1 vccd1 _0474_ sky130_fd_sc_hd__clkbuf_1
XFILLER_0_79_505 vssd1 vssd1 vccd1 vccd1 sky130_fd_sc_hd__decap_4
XFILLER_0_59_284 vssd1 vssd1 vccd1 vccd1 sky130_fd_sc_hd__fill_2
XFILLER_0_51_71 vssd1 vssd1 vccd1 vccd1 sky130_fd_sc_hd__decap_3
X_3807_ _1861_ _1737_ _1899_ vssd1 vssd1 vccd1 vccd1 _0366_ sky130_fd_sc_hd__o21ai_1
X_4787_ clknet_leaf_34_clk _0555_ vssd1 vssd1 vccd1 vccd1 u_core.u_regfile.rf\[3\]\[20\]
+ sky130_fd_sc_hd__dfxtp_1
X_3738_ _0737_ vssd1 vssd1 vccd1 vccd1 _1862_ sky130_fd_sc_hd__clkbuf_4
XFILLER_0_42_184 vccd1 vssd1 vccd1 vssd1 sky130_ef_sc_hd__decap_12
X_3669_ net197 vssd1 vssd1 vccd1 vccd1 _1827_ sky130_fd_sc_hd__clkbuf_1
XFILLER_0_80_213 vssd1 vssd1 vccd1 vccd1 sky130_fd_sc_hd__decap_3
XTAP_508 vssd1 vccd1 sky130_fd_sc_hd__tapvpwrvgnd_1
XTAP_519 vssd1 vccd1 sky130_fd_sc_hd__tapvpwrvgnd_1
XFILLER_0_56_27 vssd1 vssd1 vccd1 vccd1 sky130_fd_sc_hd__fill_1
XFILLER_0_72_15 vccd1 vssd1 vccd1 vssd1 sky130_ef_sc_hd__decap_12
X_2971_ _1028_ _0945_ _1033_ vssd1 vssd1 vccd1 vccd1 _1429_ sky130_fd_sc_hd__a21oi_1
X_4710_ clknet_leaf_47_clk _0511_ vssd1 vssd1 vccd1 vccd1 u_core.u_regfile.rf\[25\]\[16\]
+ sky130_fd_sc_hd__dfxtp_1
X_4641_ clknet_leaf_24_clk _0442_ vssd1 vssd1 vccd1 vccd1 u_core.u_regfile.rf\[26\]\[11\]
+ sky130_fd_sc_hd__dfxtp_1
XFILLER_0_71_279 vssd1 vssd1 vccd1 vccd1 sky130_fd_sc_hd__fill_1
XFILLER_0_12_302 vssd1 vssd1 vccd1 vccd1 sky130_fd_sc_hd__decap_3
XFILLER_0_21_85 vssd1 vssd1 vccd1 vccd1 sky130_fd_sc_hd__decap_6
X_4572_ clknet_leaf_31_clk _0373_ vssd1 vssd1 vccd1 vccd1 u_core.u_regfile.rf\[27\]\[6\]
+ sky130_fd_sc_hd__dfxtp_1
X_3523_ _1766_ vssd1 vssd1 vccd1 vccd1 _0215_ sky130_fd_sc_hd__clkbuf_1
X_3454_ _1412_ vssd1 vssd1 vccd1 vccd1 _1725_ sky130_fd_sc_hd__clkbuf_4
X_2405_ _0757_ net20 u_core.u_regfile.rf\[6\]\[14\] vssd1 vssd1 vccd1 vccd1 _0863_
+ sky130_fd_sc_hd__o21ai_1
X_3385_ _1671_ _1672_ _1673_ net50 vssd1 vssd1 vccd1 vccd1 _0170_ sky130_fd_sc_hd__o31a_1
X_2336_ u_core.u_regfile.rf\[31\]\[28\] _0728_ _0736_ net19 _0787_ vssd1 vssd1 vccd1
+ vccd1 _0794_ sky130_fd_sc_hd__o2111a_2
Xclkbuf_leaf_49_clk clknet_2_0__leaf_clk vssd1 vssd1 vccd1 vccd1 clknet_leaf_49_clk
+ sky130_fd_sc_hd__clkbuf_16
X_2267_ u_imem.addr\[3\] _0688_ vssd1 vssd1 vccd1 vccd1 _0725_ sky130_fd_sc_hd__nand2b_2
X_4006_ net308 vssd1 vssd1 vccd1 vccd1 _1999_ sky130_fd_sc_hd__clkbuf_1
XFILLER_0_27_3 vssd1 vssd1 vccd1 vccd1 sky130_fd_sc_hd__decap_8
X_2198_ _0624_ _0655_ _0629_ _0656_ _0623_ vssd1 vssd1 vccd1 vccd1 _0657_ sky130_fd_sc_hd__a32o_1
XFILLER_0_1_51 vssd1 vssd1 vccd1 vccd1 sky130_fd_sc_hd__decap_4
XFILLER_0_62_224 vssd1 vssd1 vccd1 vccd1 sky130_fd_sc_hd__fill_1
XFILLER_0_7_373 vccd1 vssd1 vccd1 vssd1 sky130_ef_sc_hd__decap_12
XFILLER_0_62_235 vssd1 vssd1 vccd1 vccd1 sky130_fd_sc_hd__fill_1
XFILLER_0_15_151 vssd1 vssd1 vccd1 vccd1 sky130_fd_sc_hd__fill_1
XFILLER_0_50_419 vssd1 vssd1 vccd1 vccd1 sky130_fd_sc_hd__fill_1
XFILLER_0_30_132 vssd1 vssd1 vccd1 vccd1 sky130_fd_sc_hd__decap_8
Xhold31 u_core.u_regfile.rf\[7\]\[26\] vssd1 vssd1 vccd1 vccd1 net64 sky130_fd_sc_hd__dlygate4sd3_1
Xhold20 u_core.u_regfile.rf\[5\]\[3\] vssd1 vssd1 vccd1 vccd1 net53 sky130_fd_sc_hd__dlygate4sd3_1
Xhold53 u_core.u_regfile.rf\[7\]\[3\] vssd1 vssd1 vccd1 vccd1 net86 sky130_fd_sc_hd__dlygate4sd3_1
Xhold42 u_core.u_regfile.rf\[7\]\[20\] vssd1 vssd1 vccd1 vccd1 net75 sky130_fd_sc_hd__dlygate4sd3_1
Xhold64 u_core.u_regfile.rf\[7\]\[29\] vssd1 vssd1 vccd1 vccd1 net97 sky130_fd_sc_hd__dlygate4sd3_1
Xhold86 u_core.u_regfile.rf\[6\]\[0\] vssd1 vssd1 vccd1 vccd1 net119 sky130_fd_sc_hd__dlygate4sd3_1
Xhold97 u_core.u_regfile.rf\[6\]\[20\] vssd1 vssd1 vccd1 vccd1 net130 sky130_fd_sc_hd__dlygate4sd3_1
Xhold75 u_core.u_regfile.rf\[6\]\[25\] vssd1 vssd1 vccd1 vccd1 net108 sky130_fd_sc_hd__dlygate4sd3_1
XFILLER_0_85_305 vssd1 vssd1 vccd1 vccd1 sky130_fd_sc_hd__decap_3
XFILLER_0_85_349 vccd1 vssd1 vccd1 vssd1 sky130_ef_sc_hd__decap_12
XFILLER_0_42_29 vssd1 vssd1 vccd1 vccd1 sky130_fd_sc_hd__fill_1
XFILLER_0_38_232 vccd1 vssd1 vccd1 vssd1 sky130_ef_sc_hd__decap_12
XFILLER_0_26_427 vssd1 vssd1 vccd1 vccd1 sky130_fd_sc_hd__fill_1
XFILLER_0_53_213 vssd1 vssd1 vccd1 vccd1 sky130_fd_sc_hd__decap_3
XFILLER_0_1_505 vssd1 vssd1 vccd1 vccd1 sky130_fd_sc_hd__decap_4
XTAP_305 vssd1 vccd1 sky130_fd_sc_hd__tapvpwrvgnd_1
XFILLER_0_67_15 vccd1 vssd1 vccd1 vssd1 sky130_ef_sc_hd__decap_12
XTAP_338 vssd1 vccd1 sky130_fd_sc_hd__tapvpwrvgnd_1
XTAP_327 vssd1 vccd1 sky130_fd_sc_hd__tapvpwrvgnd_1
XTAP_316 vssd1 vccd1 sky130_fd_sc_hd__tapvpwrvgnd_1
XTAP_349 vssd1 vccd1 sky130_fd_sc_hd__tapvpwrvgnd_1
X_3170_ _1585_ _1586_ vssd1 vssd1 vccd1 vccd1 _0042_ sky130_fd_sc_hd__nor2_1
X_2121_ u_timer.count_reg\[30\] _0575_ _0577_ vssd1 vssd1 vccd1 vccd1 _0580_ sky130_fd_sc_hd__o21ai_1
XFILLER_0_83_69 vccd1 vssd1 vccd1 vssd1 sky130_ef_sc_hd__decap_12
XFILLER_0_49_508 vssd1 vssd1 vccd1 vccd1 sky130_fd_sc_hd__fill_2
XFILLER_0_29_210 vssd1 vssd1 vccd1 vccd1 sky130_fd_sc_hd__fill_1
XFILLER_0_72_500 vssd1 vssd1 vccd1 vccd1 sky130_fd_sc_hd__decap_8
X_2954_ _1360_ _1411_ vssd1 vssd1 vccd1 vccd1 _1412_ sky130_fd_sc_hd__nor2_1
X_2885_ _1341_ _1291_ _1342_ vssd1 vssd1 vccd1 vccd1 _1343_ sky130_fd_sc_hd__a21oi_1
XFILLER_0_4_321 vccd1 vssd1 vccd1 vssd1 sky130_ef_sc_hd__decap_12
X_4624_ clknet_leaf_8_clk _0425_ vssd1 vssd1 vccd1 vccd1 u_core.u_regfile.rf\[1\]\[26\]
+ sky130_fd_sc_hd__dfxtp_1
XFILLER_0_12_121 vssd1 vssd1 vccd1 vccd1 sky130_fd_sc_hd__decap_6
Xhold501 u_core.u_regfile.rf\[31\]\[16\] vssd1 vssd1 vccd1 vccd1 net534 sky130_fd_sc_hd__dlygate4sd3_1
X_4555_ clknet_leaf_28_clk _0356_ vssd1 vssd1 vccd1 vccd1 u_core.u_regfile.rf\[28\]\[21\]
+ sky130_fd_sc_hd__dfxtp_1
X_3506_ net449 vssd1 vssd1 vccd1 vccd1 _1758_ sky130_fd_sc_hd__clkbuf_1
Xhold512 u_core.u_regfile.rf\[31\]\[22\] vssd1 vssd1 vccd1 vccd1 net545 sky130_fd_sc_hd__dlygate4sd3_1
Xhold523 u_core.u_regfile.rf\[31\]\[26\] vssd1 vssd1 vccd1 vccd1 net556 sky130_fd_sc_hd__dlygate4sd3_1
X_4486_ clknet_leaf_34_clk _0287_ vssd1 vssd1 vccd1 vccd1 u_core.u_regfile.rf\[30\]\[16\]
+ sky130_fd_sc_hd__dfxtp_1
XFILLER_0_40_485 vccd1 vssd1 vccd1 vssd1 sky130_ef_sc_hd__decap_12
X_3437_ _1470_ _1471_ _1677_ _1712_ vssd1 vssd1 vccd1 vccd1 _1713_ sky130_fd_sc_hd__o211a_2
XTAP_861 vssd1 vccd1 sky130_fd_sc_hd__tapvpwrvgnd_1
XTAP_850 vssd1 vccd1 sky130_fd_sc_hd__tapvpwrvgnd_1
X_3368_ _1668_ _1669_ _1670_ net83 vssd1 vssd1 vccd1 vccd1 _0156_ sky130_fd_sc_hd__o31a_1
XTAP_894 vssd1 vccd1 sky130_fd_sc_hd__tapvpwrvgnd_1
XTAP_883 vssd1 vccd1 sky130_fd_sc_hd__tapvpwrvgnd_1
XTAP_872 vssd1 vccd1 sky130_fd_sc_hd__tapvpwrvgnd_1
X_2319_ u_imem.addr\[2\] u_imem.addr\[3\] vssd1 vssd1 vccd1 vccd1 _0777_ sky130_fd_sc_hd__or2b_1
X_3299_ _1640_ vssd1 vssd1 vccd1 vccd1 _0117_ sky130_fd_sc_hd__clkbuf_1
XFILLER_0_35_202 vssd1 vssd1 vccd1 vccd1 sky130_fd_sc_hd__decap_4
XFILLER_0_35_213 vssd1 vssd1 vccd1 vccd1 sky130_fd_sc_hd__decap_4
Xoutput10 net10 vssd1 vssd1 vccd1 vccd1 gpio_pins[7] sky130_fd_sc_hd__clkbuf_4
Xoutput8 net8 vssd1 vssd1 vccd1 vccd1 gpio_pins[5] sky130_fd_sc_hd__clkbuf_4
XFILLER_0_53_39 vssd1 vssd1 vccd1 vccd1 sky130_fd_sc_hd__decap_8
XFILLER_0_58_316 vssd1 vssd1 vccd1 vccd1 sky130_fd_sc_hd__fill_1
XFILLER_0_85_113 vccd1 vssd1 vccd1 vssd1 sky130_ef_sc_hd__decap_12
XPHY_160 vssd1 vssd1 vccd1 vccd1 sky130_fd_sc_hd__decap_3
XFILLER_0_66_360 vssd1 vssd1 vccd1 vccd1 sky130_fd_sc_hd__fill_1
XPHY_171 vssd1 vssd1 vccd1 vccd1 sky130_fd_sc_hd__decap_3
XFILLER_0_81_352 vccd1 vssd1 vccd1 vssd1 sky130_ef_sc_hd__decap_12
X_2670_ _0706_ _0771_ _1125_ _1119_ vssd1 vssd1 vccd1 vccd1 _1128_ sky130_fd_sc_hd__a31o_1
XFILLER_0_41_216 vssd1 vssd1 vccd1 vccd1 sky130_fd_sc_hd__fill_2
XFILLER_0_41_238 vccd1 vssd1 vccd1 vssd1 sky130_ef_sc_hd__decap_12
XFILLER_0_1_335 vssd1 vssd1 vccd1 vccd1 sky130_fd_sc_hd__fill_1
X_4340_ clknet_leaf_44_clk _0151_ vssd1 vssd1 vccd1 vccd1 u_core.u_regfile.rf\[5\]\[8\]
+ sky130_fd_sc_hd__dfxtp_1
X_4271_ clknet_leaf_49_clk _0082_ vssd1 vssd1 vccd1 vccd1 u_core.u_regfile.rf\[6\]\[3\]
+ sky130_fd_sc_hd__dfxtp_1
X_3222_ _1612_ vssd1 vssd1 vccd1 vccd1 _0068_ sky130_fd_sc_hd__clkbuf_1
XTAP_179 vssd1 vccd1 sky130_fd_sc_hd__tapvpwrvgnd_1
X_3153_ _1564_ u_audio.counter\[4\] _1572_ _1573_ vssd1 vssd1 vccd1 vccd1 _1574_ sky130_fd_sc_hd__a22o_1
X_3084_ _1522_ _1495_ _1523_ vssd1 vssd1 vccd1 vccd1 _1524_ sky130_fd_sc_hd__and3b_1
X_3986_ net339 vssd1 vssd1 vccd1 vccd1 _1989_ sky130_fd_sc_hd__clkbuf_1
X_2937_ _1173_ _1177_ _1367_ _1178_ vssd1 vssd1 vccd1 vccd1 _1395_ sky130_fd_sc_hd__a22oi_2
XFILLER_0_72_363 vssd1 vssd1 vccd1 vccd1 sky130_fd_sc_hd__fill_1
XFILLER_0_17_279 vssd1 vssd1 vccd1 vccd1 sky130_fd_sc_hd__fill_1
X_4607_ clknet_leaf_46_clk _0408_ vssd1 vssd1 vccd1 vccd1 u_core.u_regfile.rf\[1\]\[9\]
+ sky130_fd_sc_hd__dfxtp_1
X_2868_ _0724_ _1320_ _0782_ _1325_ vssd1 vssd1 vccd1 vccd1 _1326_ sky130_fd_sc_hd__o2bb2a_1
X_2799_ _0758_ _0761_ u_core.u_regfile.rf\[6\]\[22\] vssd1 vssd1 vccd1 vccd1 _1257_
+ sky130_fd_sc_hd__o21a_1
Xhold320 u_core.u_regfile.rf\[26\]\[18\] vssd1 vssd1 vccd1 vccd1 net353 sky130_fd_sc_hd__dlygate4sd3_1
Xhold331 u_core.u_regfile.rf\[3\]\[31\] vssd1 vssd1 vccd1 vccd1 net364 sky130_fd_sc_hd__dlygate4sd3_1
Xhold353 u_core.u_regfile.rf\[4\]\[1\] vssd1 vssd1 vccd1 vccd1 net386 sky130_fd_sc_hd__dlygate4sd3_1
X_4538_ clknet_leaf_6_clk _0339_ vssd1 vssd1 vccd1 vccd1 u_core.u_regfile.rf\[28\]\[4\]
+ sky130_fd_sc_hd__dfxtp_1
Xhold342 u_core.u_regfile.rf\[29\]\[29\] vssd1 vssd1 vccd1 vccd1 net375 sky130_fd_sc_hd__dlygate4sd3_1
Xhold364 u_core.u_regfile.rf\[4\]\[16\] vssd1 vssd1 vccd1 vccd1 net397 sky130_fd_sc_hd__dlygate4sd3_1
Xhold386 u_core.u_regfile.rf\[4\]\[23\] vssd1 vssd1 vccd1 vccd1 net419 sky130_fd_sc_hd__dlygate4sd3_1
X_4469_ clknet_leaf_2_clk _0270_ vssd1 vssd1 vccd1 vccd1 u_core.u_regfile.rf\[7\]\[31\]
+ sky130_fd_sc_hd__dfxtp_1
Xhold375 u_core.u_regfile.rf\[1\]\[31\] vssd1 vssd1 vccd1 vccd1 net408 sky130_fd_sc_hd__dlygate4sd3_1
Xhold397 u_core.u_regfile.rf\[1\]\[23\] vssd1 vssd1 vccd1 vccd1 net430 sky130_fd_sc_hd__dlygate4sd3_1
XTAP_680 vssd1 vccd1 sky130_fd_sc_hd__tapvpwrvgnd_1
XTAP_691 vssd1 vccd1 sky130_fd_sc_hd__tapvpwrvgnd_1
XFILLER_0_67_113 vssd1 vssd1 vccd1 vccd1 sky130_fd_sc_hd__decap_4
XFILLER_0_36_500 vssd1 vssd1 vccd1 vccd1 sky130_fd_sc_hd__decap_8
XFILLER_0_82_138 vssd1 vssd1 vccd1 vccd1 sky130_fd_sc_hd__fill_2
XFILLER_0_51_503 vssd1 vssd1 vccd1 vccd1 sky130_fd_sc_hd__fill_1
XFILLER_0_63_396 vssd1 vssd1 vccd1 vccd1 sky130_fd_sc_hd__fill_1
XFILLER_0_64_27 vssd1 vssd1 vccd1 vccd1 sky130_fd_sc_hd__fill_1
XFILLER_0_80_15 vccd1 vssd1 vccd1 vssd1 sky130_ef_sc_hd__decap_12
X_3840_ net195 vssd1 vssd1 vccd1 vccd1 _1916_ sky130_fd_sc_hd__clkbuf_1
XFILLER_0_6_416 vssd1 vssd1 vccd1 vccd1 sky130_fd_sc_hd__decap_4
X_3771_ _1454_ _1456_ _1875_ _1881_ vssd1 vssd1 vccd1 vccd1 _0348_ sky130_fd_sc_hd__a31o_1
X_2722_ _0731_ _0761_ u_core.u_regfile.rf\[6\]\[18\] vssd1 vssd1 vccd1 vccd1 _1180_
+ sky130_fd_sc_hd__o21ai_1
XFILLER_0_54_363 vssd1 vssd1 vccd1 vccd1 sky130_fd_sc_hd__fill_1
X_2653_ _0756_ _1108_ _1109_ _1110_ _0813_ vssd1 vssd1 vccd1 vccd1 _1111_ sky130_fd_sc_hd__o311a_1
X_2584_ u_core.u_regfile.rf\[29\]\[1\] u_core.u_regfile.rf\[31\]\[1\] _0721_ vssd1
+ vssd1 vccd1 vccd1 _1042_ sky130_fd_sc_hd__mux2_1
X_4323_ clknet_leaf_40_clk _0134_ vssd1 vssd1 vccd1 vccd1 u_core.u_regfile.rf\[4\]\[23\]
+ sky130_fd_sc_hd__dfxtp_1
XFILLER_0_10_477 vccd1 vssd1 vccd1 vssd1 sky130_ef_sc_hd__decap_12
X_4254_ clknet_leaf_27_clk _0069_ vssd1 vssd1 vccd1 vccd1 u_core.u_regfile.rf\[31\]\[22\]
+ sky130_fd_sc_hd__dfxtp_1
X_3205_ net530 vssd1 vssd1 vccd1 vccd1 _1604_ sky130_fd_sc_hd__clkbuf_1
XFILLER_0_38_83 vssd1 vssd1 vccd1 vccd1 sky130_fd_sc_hd__fill_1
X_4185_ _2092_ vssd1 vssd1 vccd1 vccd1 _0551_ sky130_fd_sc_hd__clkbuf_1
X_3136_ u_timer.count_reg\[30\] u_timer.count_reg\[29\] u_timer.count_reg\[28\] _1552_
+ vssd1 vssd1 vccd1 vccd1 _1559_ sky130_fd_sc_hd__and4_1
X_3067_ _1509_ _1495_ _1510_ vssd1 vssd1 vccd1 vccd1 _1511_ sky130_fd_sc_hd__and3b_1
XFILLER_0_49_157 vssd1 vssd1 vccd1 vccd1 sky130_fd_sc_hd__decap_4
XFILLER_0_18_500 vssd1 vssd1 vccd1 vccd1 sky130_fd_sc_hd__decap_8
XFILLER_0_37_319 vssd1 vssd1 vccd1 vccd1 sky130_fd_sc_hd__fill_1
X_3969_ _1980_ vssd1 vssd1 vccd1 vccd1 _0447_ sky130_fd_sc_hd__clkbuf_1
Xhold150 u_core.u_regfile.rf\[25\]\[31\] vssd1 vssd1 vccd1 vccd1 net183 sky130_fd_sc_hd__dlygate4sd3_1
Xhold161 u_core.u_regfile.rf\[30\]\[15\] vssd1 vssd1 vccd1 vccd1 net194 sky130_fd_sc_hd__dlygate4sd3_1
Xhold172 u_core.u_regfile.rf\[25\]\[27\] vssd1 vssd1 vccd1 vccd1 net205 sky130_fd_sc_hd__dlygate4sd3_1
Xhold194 u_core.u_regfile.rf\[2\]\[14\] vssd1 vssd1 vccd1 vccd1 net227 sky130_fd_sc_hd__dlygate4sd3_1
Xhold183 u_core.u_regfile.rf\[3\]\[17\] vssd1 vssd1 vccd1 vccd1 net216 sky130_fd_sc_hd__dlygate4sd3_1
XFILLER_0_68_488 vccd1 vssd1 vccd1 vssd1 sky130_ef_sc_hd__decap_12
XFILLER_0_83_447 vssd1 vssd1 vccd1 vccd1 sky130_fd_sc_hd__fill_1
XFILLER_0_50_29 vssd1 vssd1 vccd1 vccd1 sky130_fd_sc_hd__decap_6
XFILLER_0_59_27 vssd1 vssd1 vccd1 vccd1 sky130_fd_sc_hd__decap_8
XFILLER_0_75_15 vccd1 vssd1 vccd1 vssd1 sky130_ef_sc_hd__decap_12
XFILLER_0_59_422 vssd1 vssd1 vccd1 vccd1 sky130_fd_sc_hd__decap_4
XFILLER_0_24_85 vssd1 vssd1 vccd1 vccd1 sky130_fd_sc_hd__fill_1
X_3823_ _1907_ vssd1 vssd1 vccd1 vccd1 _0374_ sky130_fd_sc_hd__clkbuf_1
XFILLER_0_46_138 vssd1 vssd1 vccd1 vccd1 sky130_fd_sc_hd__fill_2
X_3754_ _1871_ vssd1 vssd1 vccd1 vccd1 _0341_ sky130_fd_sc_hd__clkbuf_1
X_3685_ net200 vssd1 vssd1 vccd1 vccd1 _1835_ sky130_fd_sc_hd__clkbuf_1
X_2705_ _0780_ _1158_ _1162_ vssd1 vssd1 vccd1 vccd1 _1163_ sky130_fd_sc_hd__o21bai_2
X_2636_ _1091_ _1092_ _1093_ vssd1 vssd1 vccd1 vccd1 _1094_ sky130_fd_sc_hd__a21oi_4
X_2567_ u_core.u_regfile.rf\[7\]\[0\] _0753_ _0713_ vssd1 vssd1 vccd1 vccd1 _1025_
+ sky130_fd_sc_hd__nand3b_1
XFILLER_0_49_60 vssd1 vssd1 vccd1 vccd1 sky130_fd_sc_hd__fill_1
XFILLER_0_57_3 vccd1 vssd1 vccd1 vssd1 sky130_ef_sc_hd__decap_12
X_2498_ _0770_ _0953_ _0702_ _0909_ _0955_ vssd1 vssd1 vccd1 vccd1 _0956_ sky130_fd_sc_hd__a221o_1
X_4306_ clknet_leaf_3_clk _0117_ vssd1 vssd1 vccd1 vccd1 u_core.u_regfile.rf\[4\]\[6\]
+ sky130_fd_sc_hd__dfxtp_1
XFILLER_0_4_40 vssd1 vssd1 vccd1 vccd1 sky130_fd_sc_hd__decap_4
X_4237_ clknet_leaf_6_clk _0052_ vssd1 vssd1 vccd1 vccd1 u_core.u_regfile.rf\[31\]\[5\]
+ sky130_fd_sc_hd__dfxtp_1
X_4168_ net151 vssd1 vssd1 vccd1 vccd1 _2084_ sky130_fd_sc_hd__clkbuf_1
X_3119_ u_timer.count_reg\[24\] u_timer.count_reg\[23\] u_timer.count_reg\[22\] _1541_
+ u_timer.count_reg\[25\] vssd1 vssd1 vccd1 vccd1 _1547_ sky130_fd_sc_hd__a41o_1
X_4099_ _2045_ vssd1 vssd1 vccd1 vccd1 _0512_ sky130_fd_sc_hd__clkbuf_1
XFILLER_0_60_141 vssd1 vssd1 vccd1 vccd1 sky130_fd_sc_hd__decap_3
XFILLER_0_28_105 vssd1 vssd1 vccd1 vccd1 sky130_fd_sc_hd__fill_1
XFILLER_0_28_127 vssd1 vssd1 vccd1 vccd1 sky130_fd_sc_hd__decap_4
X_3470_ _1472_ _1735_ _1712_ vssd1 vssd1 vccd1 vccd1 _1736_ sky130_fd_sc_hd__or3b_2
X_2421_ _0692_ vssd1 vssd1 vccd1 vccd1 _0879_ sky130_fd_sc_hd__buf_6
X_2352_ _0715_ u_core.u_regfile.rf\[7\]\[26\] _0754_ _0756_ _0809_ vssd1 vssd1 vccd1
+ vccd1 _0810_ sky130_fd_sc_hd__a311o_1
X_2283_ _0740_ vssd1 vssd1 vccd1 vccd1 _0741_ sky130_fd_sc_hd__clkbuf_4
XFILLER_0_19_96 vssd1 vssd1 vccd1 vccd1 sky130_fd_sc_hd__decap_4
X_4022_ net221 vssd1 vssd1 vccd1 vccd1 _2007_ sky130_fd_sc_hd__clkbuf_1
XFILLER_0_74_200 vssd1 vssd1 vccd1 vccd1 sky130_fd_sc_hd__decap_3
X_4786_ clknet_leaf_50_clk _0554_ vssd1 vssd1 vccd1 vccd1 u_core.u_regfile.rf\[3\]\[19\]
+ sky130_fd_sc_hd__dfxtp_1
X_3806_ _1674_ _1862_ net105 vssd1 vssd1 vccd1 vccd1 _1899_ sky130_fd_sc_hd__o21ai_1
X_3737_ _1133_ vssd1 vssd1 vccd1 vccd1 _1861_ sky130_fd_sc_hd__buf_4
XFILLER_0_42_141 vssd1 vssd1 vccd1 vccd1 sky130_fd_sc_hd__fill_2
X_3668_ _1826_ vssd1 vssd1 vccd1 vccd1 _0300_ sky130_fd_sc_hd__clkbuf_1
X_3599_ _1794_ _1795_ _1796_ net96 vssd1 vssd1 vccd1 vccd1 _0261_ sky130_fd_sc_hd__o31a_1
X_2619_ _0758_ _0954_ u_core.u_regfile.rf\[28\]\[5\] vssd1 vssd1 vccd1 vccd1 _1077_
+ sky130_fd_sc_hd__o21ai_1
XFILLER_0_85_509 vssd1 vssd1 vccd1 vccd1 sky130_fd_sc_hd__fill_1
XFILLER_0_65_211 vccd1 vssd1 vccd1 vssd1 sky130_ef_sc_hd__decap_12
XFILLER_0_33_141 vccd1 vssd1 vccd1 vssd1 sky130_ef_sc_hd__decap_12
XTAP_509 vssd1 vccd1 sky130_fd_sc_hd__tapvpwrvgnd_1
XFILLER_0_76_509 vssd1 vssd1 vccd1 vccd1 sky130_fd_sc_hd__fill_1
XFILLER_0_72_27 vssd1 vssd1 vccd1 vccd1 sky130_fd_sc_hd__fill_1
X_2970_ _1049_ _1033_ _1425_ _1426_ _1427_ vssd1 vssd1 vccd1 vccd1 _1428_ sky130_fd_sc_hd__a41o_1
XFILLER_0_29_469 vssd1 vssd1 vccd1 vccd1 sky130_fd_sc_hd__decap_8
XFILLER_0_71_225 vssd1 vssd1 vccd1 vccd1 sky130_fd_sc_hd__fill_2
X_4640_ clknet_leaf_41_clk _0441_ vssd1 vssd1 vccd1 vccd1 u_core.u_regfile.rf\[26\]\[10\]
+ sky130_fd_sc_hd__dfxtp_1
X_4571_ clknet_leaf_33_clk _0372_ vssd1 vssd1 vccd1 vccd1 u_core.u_regfile.rf\[27\]\[5\]
+ sky130_fd_sc_hd__dfxtp_1
XFILLER_0_12_325 vssd1 vssd1 vccd1 vccd1 sky130_fd_sc_hd__fill_1
X_3522_ net412 vssd1 vssd1 vccd1 vccd1 _1766_ sky130_fd_sc_hd__clkbuf_1
X_3453_ _0916_ _1126_ vssd1 vssd1 vccd1 vccd1 _1724_ sky130_fd_sc_hd__or2b_1
X_2404_ _0860_ u_core.u_regfile.rf\[7\]\[14\] _0861_ vssd1 vssd1 vccd1 vccd1 _0862_
+ sky130_fd_sc_hd__nand3_1
X_3384_ _1671_ _1672_ _1673_ net49 vssd1 vssd1 vccd1 vccd1 _0169_ sky130_fd_sc_hd__o31a_1
X_2335_ _0782_ _0788_ _0792_ vssd1 vssd1 vccd1 vccd1 _0793_ sky130_fd_sc_hd__or3b_2
X_2266_ _0723_ vssd1 vssd1 vccd1 vccd1 _0724_ sky130_fd_sc_hd__buf_4
X_2197_ _0620_ u_timer.count_reg\[10\] _0621_ u_timer.count_reg\[11\] vssd1 vssd1
+ vccd1 vccd1 _0656_ sky130_fd_sc_hd__a22o_1
X_4005_ _1998_ vssd1 vssd1 vccd1 vccd1 _0465_ sky130_fd_sc_hd__clkbuf_1
XFILLER_0_67_509 vssd1 vssd1 vccd1 vccd1 sky130_fd_sc_hd__fill_1
XFILLER_0_7_330 vssd1 vssd1 vccd1 vccd1 sky130_fd_sc_hd__decap_3
XFILLER_0_62_247 vssd1 vssd1 vccd1 vccd1 sky130_fd_sc_hd__decap_4
XFILLER_0_7_385 vssd1 vssd1 vccd1 vccd1 sky130_fd_sc_hd__decap_6
X_4769_ clknet_leaf_33_clk _0537_ vssd1 vssd1 vccd1 vccd1 u_core.u_regfile.rf\[3\]\[2\]
+ sky130_fd_sc_hd__dfxtp_1
XFILLER_0_15_185 vssd1 vssd1 vccd1 vccd1 sky130_fd_sc_hd__fill_1
XFILLER_0_43_494 vssd1 vssd1 vccd1 vccd1 sky130_fd_sc_hd__fill_2
XFILLER_0_11_391 vssd1 vssd1 vccd1 vccd1 sky130_fd_sc_hd__fill_1
Xhold21 u_core.u_regfile.rf\[7\]\[0\] vssd1 vssd1 vccd1 vccd1 net54 sky130_fd_sc_hd__dlygate4sd3_1
Xhold10 u_core.u_regfile.rf\[5\]\[7\] vssd1 vssd1 vccd1 vccd1 net43 sky130_fd_sc_hd__dlygate4sd3_1
Xhold32 u_core.u_regfile.rf\[28\]\[23\] vssd1 vssd1 vccd1 vccd1 net65 sky130_fd_sc_hd__dlygate4sd3_1
Xhold43 u_core.u_regfile.rf\[7\]\[18\] vssd1 vssd1 vccd1 vccd1 net76 sky130_fd_sc_hd__dlygate4sd3_1
Xhold65 u_core.u_regfile.rf\[5\]\[11\] vssd1 vssd1 vccd1 vccd1 net98 sky130_fd_sc_hd__dlygate4sd3_1
Xhold54 u_core.u_regfile.rf\[7\]\[27\] vssd1 vssd1 vccd1 vccd1 net87 sky130_fd_sc_hd__dlygate4sd3_1
Xhold87 u_core.u_regfile.rf\[6\]\[7\] vssd1 vssd1 vccd1 vccd1 net120 sky130_fd_sc_hd__dlygate4sd3_1
Xhold76 u_core.u_regfile.rf\[6\]\[24\] vssd1 vssd1 vccd1 vccd1 net109 sky130_fd_sc_hd__dlygate4sd3_1
Xhold98 u_core.u_regfile.rf\[5\]\[2\] vssd1 vssd1 vccd1 vccd1 net131 sky130_fd_sc_hd__dlygate4sd3_1
XFILLER_0_78_380 vccd1 vssd1 vccd1 vssd1 sky130_ef_sc_hd__decap_12
XFILLER_0_41_409 vssd1 vssd1 vccd1 vccd1 sky130_fd_sc_hd__fill_1
XTAP_306 vssd1 vccd1 sky130_fd_sc_hd__tapvpwrvgnd_1
XFILLER_0_67_27 vssd1 vssd1 vccd1 vccd1 sky130_fd_sc_hd__decap_8
XTAP_339 vssd1 vccd1 sky130_fd_sc_hd__tapvpwrvgnd_1
XTAP_328 vssd1 vccd1 sky130_fd_sc_hd__tapvpwrvgnd_1
XTAP_317 vssd1 vccd1 sky130_fd_sc_hd__tapvpwrvgnd_1
XFILLER_0_83_15 vccd1 vssd1 vccd1 vssd1 sky130_ef_sc_hd__decap_12
X_2120_ u_timer.count_reg\[29\] vssd1 vssd1 vccd1 vccd1 _0579_ sky130_fd_sc_hd__inv_2
X_2953_ _1383_ _1402_ _1410_ vssd1 vssd1 vccd1 vccd1 _1411_ sky130_fd_sc_hd__nand3_1
XFILLER_0_69_391 vssd1 vssd1 vccd1 vccd1 sky130_fd_sc_hd__fill_1
X_2884_ _1221_ _1223_ _1276_ vssd1 vssd1 vccd1 vccd1 _1342_ sky130_fd_sc_hd__or3_2
XFILLER_0_4_333 vccd1 vssd1 vccd1 vssd1 sky130_ef_sc_hd__decap_12
X_4623_ clknet_leaf_8_clk _0424_ vssd1 vssd1 vccd1 vccd1 u_core.u_regfile.rf\[1\]\[25\]
+ sky130_fd_sc_hd__dfxtp_1
Xhold502 u_core.u_regfile.rf\[31\]\[21\] vssd1 vssd1 vccd1 vccd1 net535 sky130_fd_sc_hd__dlygate4sd3_1
X_4554_ clknet_leaf_28_clk _0355_ vssd1 vssd1 vccd1 vccd1 u_core.u_regfile.rf\[28\]\[20\]
+ sky130_fd_sc_hd__dfxtp_1
X_3505_ _1325_ _1680_ _1757_ vssd1 vssd1 vccd1 vccd1 _0206_ sky130_fd_sc_hd__o21ai_1
Xhold524 u_core.u_regfile.rf\[31\]\[27\] vssd1 vssd1 vccd1 vccd1 net557 sky130_fd_sc_hd__dlygate4sd3_1
Xhold513 u_timer.threshold_reg\[10\] vssd1 vssd1 vccd1 vccd1 net546 sky130_fd_sc_hd__dlygate4sd3_1
X_4485_ clknet_leaf_31_clk _0286_ vssd1 vssd1 vccd1 vccd1 u_core.u_regfile.rf\[30\]\[15\]
+ sky130_fd_sc_hd__dfxtp_1
XFILLER_0_40_497 vssd1 vssd1 vccd1 vccd1 sky130_fd_sc_hd__fill_2
X_3436_ _1418_ _1707_ _1416_ _1711_ vssd1 vssd1 vccd1 vccd1 _1712_ sky130_fd_sc_hd__nor4_1
XTAP_862 vssd1 vccd1 sky130_fd_sc_hd__tapvpwrvgnd_1
XTAP_851 vssd1 vccd1 sky130_fd_sc_hd__tapvpwrvgnd_1
XTAP_840 vssd1 vccd1 sky130_fd_sc_hd__tapvpwrvgnd_1
X_3367_ _1668_ _1669_ _1670_ net492 vssd1 vssd1 vccd1 vccd1 _0155_ sky130_fd_sc_hd__o31a_1
XTAP_895 vssd1 vccd1 sky130_fd_sc_hd__tapvpwrvgnd_1
XTAP_884 vssd1 vccd1 sky130_fd_sc_hd__tapvpwrvgnd_1
XTAP_873 vssd1 vccd1 sky130_fd_sc_hd__tapvpwrvgnd_1
X_2318_ _0685_ vssd1 vssd1 vccd1 vccd1 _0776_ sky130_fd_sc_hd__clkbuf_4
XFILLER_0_57_93 vssd1 vssd1 vccd1 vccd1 sky130_fd_sc_hd__decap_3
X_3298_ net421 vssd1 vssd1 vccd1 vccd1 _1640_ sky130_fd_sc_hd__clkbuf_1
X_2249_ _0706_ vssd1 vssd1 vccd1 vccd1 _0707_ sky130_fd_sc_hd__clkbuf_4
XFILLER_0_79_166 vssd1 vssd1 vccd1 vccd1 sky130_fd_sc_hd__fill_2
XFILLER_0_73_81 vccd1 vssd1 vccd1 vssd1 sky130_ef_sc_hd__decap_12
XFILLER_0_50_217 vssd1 vssd1 vccd1 vccd1 sky130_fd_sc_hd__fill_2
Xoutput9 net9 vssd1 vssd1 vccd1 vccd1 gpio_pins[6] sky130_fd_sc_hd__clkbuf_4
XFILLER_0_9_3 vccd1 vssd1 vccd1 vssd1 sky130_ef_sc_hd__decap_12
XFILLER_0_85_125 vccd1 vssd1 vccd1 vssd1 sky130_ef_sc_hd__decap_12
XFILLER_0_73_309 vccd1 vssd1 vccd1 vssd1 sky130_ef_sc_hd__decap_12
XFILLER_0_85_169 vccd1 vssd1 vccd1 vssd1 sky130_ef_sc_hd__decap_12
XPHY_161 vssd1 vssd1 vccd1 vccd1 sky130_fd_sc_hd__decap_3
XPHY_150 vssd1 vssd1 vccd1 vccd1 sky130_fd_sc_hd__decap_3
XFILLER_0_54_501 vssd1 vssd1 vccd1 vccd1 sky130_fd_sc_hd__decap_8
XFILLER_0_26_236 vssd1 vssd1 vccd1 vccd1 sky130_fd_sc_hd__decap_8
XFILLER_0_81_364 vccd1 vssd1 vccd1 vssd1 sky130_ef_sc_hd__decap_12
XFILLER_0_78_15 vccd1 vssd1 vccd1 vssd1 sky130_ef_sc_hd__decap_12
X_4270_ clknet_leaf_49_clk _0081_ vssd1 vssd1 vccd1 vccd1 u_core.u_regfile.rf\[6\]\[2\]
+ sky130_fd_sc_hd__dfxtp_1
XFILLER_0_22_497 vccd1 vssd1 vccd1 vssd1 sky130_ef_sc_hd__decap_12
X_3221_ net535 vssd1 vssd1 vccd1 vccd1 _1612_ sky130_fd_sc_hd__clkbuf_1
X_3152_ u_audio.counter\[3\] _1565_ vssd1 vssd1 vccd1 vccd1 _1573_ sky130_fd_sc_hd__or2_1
X_3083_ u_timer.count_reg\[12\] u_timer.count_reg\[11\] u_timer.count_reg\[10\] _1518_
+ u_timer.count_reg\[13\] vssd1 vssd1 vccd1 vccd1 _1523_ sky130_fd_sc_hd__a41o_1
XFILLER_0_43_73 vssd1 vssd1 vccd1 vccd1 sky130_fd_sc_hd__fill_2
XFILLER_0_9_447 vssd1 vssd1 vccd1 vccd1 sky130_fd_sc_hd__fill_1
X_3985_ _1988_ vssd1 vssd1 vccd1 vccd1 _0455_ sky130_fd_sc_hd__clkbuf_1
XFILLER_0_64_309 vccd1 vssd1 vccd1 vssd1 sky130_ef_sc_hd__decap_12
XFILLER_0_84_191 vssd1 vssd1 vccd1 vccd1 sky130_fd_sc_hd__decap_4
X_2936_ _1371_ _1297_ vssd1 vssd1 vccd1 vccd1 _1394_ sky130_fd_sc_hd__nand2_1
X_2867_ u_core.u_regfile.rf\[31\]\[31\] _0728_ _1321_ _1324_ net19 vssd1 vssd1 vccd1
+ vccd1 _1325_ sky130_fd_sc_hd__o221ai_4
X_4606_ clknet_leaf_40_clk _0407_ vssd1 vssd1 vccd1 vccd1 u_core.u_regfile.rf\[1\]\[8\]
+ sky130_fd_sc_hd__dfxtp_1
XFILLER_0_4_141 vssd1 vssd1 vccd1 vccd1 sky130_fd_sc_hd__decap_3
XFILLER_0_32_228 vssd1 vssd1 vccd1 vccd1 sky130_fd_sc_hd__decap_3
Xhold310 u_core.u_regfile.rf\[2\]\[28\] vssd1 vssd1 vccd1 vccd1 net343 sky130_fd_sc_hd__dlygate4sd3_1
X_2798_ _1239_ _1245_ _1250_ _1255_ vssd1 vssd1 vccd1 vccd1 _1256_ sky130_fd_sc_hd__o31ai_1
XFILLER_0_13_475 vssd1 vssd1 vccd1 vccd1 sky130_fd_sc_hd__decap_8
XFILLER_0_7_51 vssd1 vssd1 vccd1 vccd1 sky130_fd_sc_hd__decap_4
XFILLER_0_40_250 vssd1 vssd1 vccd1 vccd1 sky130_fd_sc_hd__fill_2
XFILLER_0_40_261 vssd1 vssd1 vccd1 vccd1 sky130_fd_sc_hd__fill_1
Xhold343 u_core.u_regfile.rf\[3\]\[16\] vssd1 vssd1 vccd1 vccd1 net376 sky130_fd_sc_hd__dlygate4sd3_1
X_4537_ clknet_leaf_6_clk _0338_ vssd1 vssd1 vccd1 vccd1 u_core.u_regfile.rf\[28\]\[3\]
+ sky130_fd_sc_hd__dfxtp_1
Xhold321 u_core.u_regfile.rf\[30\]\[4\] vssd1 vssd1 vccd1 vccd1 net354 sky130_fd_sc_hd__dlygate4sd3_1
Xhold332 u_audio.counter\[0\] vssd1 vssd1 vccd1 vccd1 net365 sky130_fd_sc_hd__dlygate4sd3_1
Xhold354 u_core.u_regfile.rf\[29\]\[12\] vssd1 vssd1 vccd1 vccd1 net387 sky130_fd_sc_hd__dlygate4sd3_1
Xhold387 u_core.u_regfile.rf\[4\]\[18\] vssd1 vssd1 vccd1 vccd1 net420 sky130_fd_sc_hd__dlygate4sd3_1
X_4468_ clknet_leaf_2_clk _0269_ vssd1 vssd1 vccd1 vccd1 u_core.u_regfile.rf\[7\]\[30\]
+ sky130_fd_sc_hd__dfxtp_1
Xhold365 u_core.u_regfile.rf\[29\]\[3\] vssd1 vssd1 vccd1 vccd1 net398 sky130_fd_sc_hd__dlygate4sd3_1
Xhold376 u_core.u_regfile.rf\[29\]\[22\] vssd1 vssd1 vccd1 vccd1 net409 sky130_fd_sc_hd__dlygate4sd3_1
Xhold398 u_core.u_regfile.rf\[1\]\[5\] vssd1 vssd1 vccd1 vccd1 net431 sky130_fd_sc_hd__dlygate4sd3_1
XFILLER_0_0_380 vccd1 vssd1 vccd1 vssd1 sky130_ef_sc_hd__decap_12
X_3419_ _1085_ vssd1 vssd1 vccd1 vccd1 _1698_ sky130_fd_sc_hd__inv_2
X_4399_ clknet_leaf_7_clk _0210_ vssd1 vssd1 vccd1 vccd1 u_core.u_regfile.rf\[29\]\[3\]
+ sky130_fd_sc_hd__dfxtp_1
XTAP_670 vssd1 vccd1 sky130_fd_sc_hd__tapvpwrvgnd_1
XTAP_681 vssd1 vccd1 sky130_fd_sc_hd__tapvpwrvgnd_1
XTAP_692 vssd1 vccd1 sky130_fd_sc_hd__tapvpwrvgnd_1
XFILLER_0_48_361 vssd1 vssd1 vccd1 vccd1 sky130_fd_sc_hd__decap_3
XFILLER_0_67_169 vssd1 vssd1 vccd1 vccd1 sky130_fd_sc_hd__fill_1
XFILLER_0_82_128 vssd1 vssd1 vccd1 vccd1 sky130_fd_sc_hd__decap_3
XFILLER_0_63_375 vssd1 vssd1 vccd1 vccd1 sky130_fd_sc_hd__fill_2
XFILLER_0_48_29 vccd1 vssd1 vccd1 vssd1 sky130_ef_sc_hd__decap_12
XFILLER_0_80_27 vssd1 vssd1 vccd1 vccd1 sky130_fd_sc_hd__fill_1
XFILLER_0_39_350 vssd1 vssd1 vccd1 vccd1 sky130_fd_sc_hd__decap_3
XFILLER_0_46_309 vssd1 vssd1 vccd1 vccd1 sky130_fd_sc_hd__decap_8
X_3770_ _1876_ _1877_ net452 vssd1 vssd1 vccd1 vccd1 _1881_ sky130_fd_sc_hd__o21a_1
XFILLER_0_13_87 vssd1 vssd1 vccd1 vccd1 sky130_fd_sc_hd__fill_1
XFILLER_0_6_439 vssd1 vssd1 vccd1 vccd1 sky130_fd_sc_hd__fill_1
X_2721_ _0913_ u_core.u_regfile.rf\[1\]\[18\] _0858_ _0914_ vssd1 vssd1 vccd1 vccd1
+ _1179_ sky130_fd_sc_hd__a31o_1
XFILLER_0_54_342 vssd1 vssd1 vccd1 vccd1 sky130_fd_sc_hd__decap_3
XFILLER_0_81_194 vssd1 vssd1 vccd1 vccd1 sky130_fd_sc_hd__fill_1
X_2652_ _0700_ _0802_ u_core.u_regfile.rf\[4\]\[6\] vssd1 vssd1 vccd1 vccd1 _1110_
+ sky130_fd_sc_hd__a21o_1
X_2583_ _1035_ _1039_ _1040_ vssd1 vssd1 vccd1 vccd1 _1041_ sky130_fd_sc_hd__o21bai_4
XFILLER_0_1_111 vssd1 vssd1 vccd1 vccd1 sky130_fd_sc_hd__fill_1
X_4322_ clknet_leaf_44_clk _0133_ vssd1 vssd1 vccd1 vccd1 u_core.u_regfile.rf\[4\]\[22\]
+ sky130_fd_sc_hd__dfxtp_1
X_4253_ clknet_leaf_27_clk _0068_ vssd1 vssd1 vccd1 vccd1 u_core.u_regfile.rf\[31\]\[21\]
+ sky130_fd_sc_hd__dfxtp_1
X_3204_ _1603_ vssd1 vssd1 vccd1 vccd1 _0059_ sky130_fd_sc_hd__clkbuf_1
XFILLER_0_10_489 vssd1 vssd1 vccd1 vccd1 sky130_fd_sc_hd__decap_8
X_4184_ net376 vssd1 vssd1 vccd1 vccd1 _2092_ sky130_fd_sc_hd__clkbuf_1
X_3135_ _0579_ _1555_ _1558_ _0001_ vssd1 vssd1 vccd1 vccd1 _0028_ sky130_fd_sc_hd__a211oi_1
X_3066_ u_timer.count_reg\[8\] u_timer.count_reg\[7\] _1502_ u_timer.count_reg\[9\]
+ vssd1 vssd1 vccd1 vccd1 _1510_ sky130_fd_sc_hd__a31o_1
XFILLER_0_77_401 vssd1 vssd1 vccd1 vccd1 sky130_fd_sc_hd__fill_2
XFILLER_0_54_83 vssd1 vssd1 vccd1 vccd1 sky130_fd_sc_hd__fill_1
XFILLER_0_49_169 vssd1 vssd1 vccd1 vccd1 sky130_fd_sc_hd__decap_4
X_3968_ net185 vssd1 vssd1 vccd1 vccd1 _1980_ sky130_fd_sc_hd__clkbuf_1
XFILLER_0_57_191 vssd1 vssd1 vccd1 vccd1 sky130_fd_sc_hd__decap_8
X_2919_ _0845_ _1376_ _0833_ vssd1 vssd1 vccd1 vccd1 _1377_ sky130_fd_sc_hd__o21bai_1
XFILLER_0_72_161 vssd1 vssd1 vccd1 vccd1 sky130_fd_sc_hd__decap_3
X_3899_ _1945_ vssd1 vssd1 vccd1 vccd1 _0412_ sky130_fd_sc_hd__clkbuf_1
XFILLER_0_5_461 vssd1 vssd1 vccd1 vccd1 sky130_fd_sc_hd__decap_3
Xhold162 u_core.u_regfile.rf\[27\]\[16\] vssd1 vssd1 vccd1 vccd1 net195 sky130_fd_sc_hd__dlygate4sd3_1
Xhold140 u_core.u_regfile.rf\[3\]\[14\] vssd1 vssd1 vccd1 vccd1 net173 sky130_fd_sc_hd__dlygate4sd3_1
Xhold151 u_core.u_regfile.rf\[26\]\[11\] vssd1 vssd1 vccd1 vccd1 net184 sky130_fd_sc_hd__dlygate4sd3_1
Xhold173 u_core.u_regfile.rf\[26\]\[21\] vssd1 vssd1 vccd1 vccd1 net206 sky130_fd_sc_hd__dlygate4sd3_1
Xhold184 u_core.u_regfile.rf\[24\]\[5\] vssd1 vssd1 vccd1 vccd1 net217 sky130_fd_sc_hd__dlygate4sd3_1
Xhold195 u_core.u_regfile.rf\[24\]\[24\] vssd1 vssd1 vccd1 vccd1 net228 sky130_fd_sc_hd__dlygate4sd3_1
XFILLER_0_75_27 vccd1 vssd1 vccd1 vssd1 sky130_ef_sc_hd__decap_12
XFILLER_0_74_437 vssd1 vssd1 vccd1 vccd1 sky130_fd_sc_hd__fill_1
X_3822_ net211 vssd1 vssd1 vccd1 vccd1 _1907_ sky130_fd_sc_hd__clkbuf_1
XFILLER_0_6_203 vssd1 vssd1 vccd1 vccd1 sky130_fd_sc_hd__fill_1
XFILLER_0_27_364 vssd1 vssd1 vccd1 vccd1 sky130_fd_sc_hd__decap_6
X_3753_ _1870_ net509 _1868_ vssd1 vssd1 vccd1 vccd1 _1871_ sky130_fd_sc_hd__mux2_1
XFILLER_0_54_150 vssd1 vssd1 vccd1 vccd1 sky130_fd_sc_hd__decap_6
X_3684_ _1834_ vssd1 vssd1 vccd1 vccd1 _0308_ sky130_fd_sc_hd__clkbuf_1
X_2704_ _0771_ _0774_ _0879_ u_core.u_regfile.rf\[5\]\[19\] _1161_ vssd1 vssd1 vccd1
+ vccd1 _1162_ sky130_fd_sc_hd__o221ai_4
X_2635_ u_core.u_regfile.rf\[31\]\[4\] _0726_ _0858_ _0758_ vssd1 vssd1 vccd1 vccd1
+ _1093_ sky130_fd_sc_hd__a2bb2o_2
XFILLER_0_2_475 vssd1 vssd1 vccd1 vccd1 sky130_fd_sc_hd__fill_1
X_2566_ _0757_ _0761_ u_core.u_regfile.rf\[6\]\[0\] vssd1 vssd1 vccd1 vccd1 _1024_
+ sky130_fd_sc_hd__o21bai_1
X_4305_ clknet_leaf_45_clk _0116_ vssd1 vssd1 vccd1 vccd1 u_core.u_regfile.rf\[4\]\[5\]
+ sky130_fd_sc_hd__dfxtp_1
XFILLER_0_10_253 vssd1 vssd1 vccd1 vccd1 sky130_fd_sc_hd__decap_4
X_2497_ _0922_ _0954_ u_core.u_regfile.rf\[28\]\[8\] vssd1 vssd1 vccd1 vccd1 _0955_
+ sky130_fd_sc_hd__o21a_1
X_4236_ clknet_leaf_8_clk _0051_ vssd1 vssd1 vccd1 vccd1 u_core.u_regfile.rf\[31\]\[4\]
+ sky130_fd_sc_hd__dfxtp_1
XFILLER_0_4_85 vssd1 vssd1 vccd1 vccd1 sky130_fd_sc_hd__decap_4
X_4167_ _2083_ vssd1 vssd1 vccd1 vccd1 _0542_ sky130_fd_sc_hd__clkbuf_1
X_3118_ u_timer.count_reg\[25\] u_timer.count_reg\[24\] _1544_ vssd1 vssd1 vccd1 vccd1
+ _1546_ sky130_fd_sc_hd__and3_1
XFILLER_0_65_93 vssd1 vssd1 vccd1 vccd1 sky130_fd_sc_hd__fill_2
X_4098_ net214 vssd1 vssd1 vccd1 vccd1 _2045_ sky130_fd_sc_hd__clkbuf_1
X_3049_ u_timer.count_reg\[4\] u_timer.count_reg\[3\] _1492_ vssd1 vssd1 vccd1 vccd1
+ _1498_ sky130_fd_sc_hd__and3_1
XFILLER_0_81_81 vccd1 vssd1 vccd1 vssd1 sky130_ef_sc_hd__decap_12
XFILLER_0_77_286 vccd1 vssd1 vccd1 vssd1 sky130_ef_sc_hd__decap_12
XFILLER_0_65_437 vssd1 vssd1 vccd1 vccd1 sky130_fd_sc_hd__fill_1
XFILLER_0_33_301 vccd1 vssd1 vccd1 vssd1 sky130_ef_sc_hd__decap_12
XFILLER_0_83_223 vssd1 vssd1 vccd1 vccd1 sky130_fd_sc_hd__fill_1
XFILLER_0_83_212 vssd1 vssd1 vccd1 vccd1 sky130_fd_sc_hd__fill_1
XFILLER_0_28_139 vssd1 vssd1 vccd1 vccd1 sky130_fd_sc_hd__fill_1
XFILLER_0_36_172 vssd1 vssd1 vccd1 vccd1 sky130_fd_sc_hd__fill_2
XFILLER_0_12_507 vssd1 vssd1 vccd1 vccd1 sky130_fd_sc_hd__decap_3
XFILLER_0_24_389 vccd1 vssd1 vccd1 vssd1 sky130_ef_sc_hd__decap_12
X_2420_ _0877_ vssd1 vssd1 vccd1 vccd1 _0878_ sky130_fd_sc_hd__clkbuf_4
X_2351_ _0808_ _0762_ u_core.u_regfile.rf\[6\]\[26\] vssd1 vssd1 vccd1 vccd1 _0809_
+ sky130_fd_sc_hd__o21a_1
X_2282_ _0686_ vssd1 vssd1 vccd1 vccd1 _0740_ sky130_fd_sc_hd__clkbuf_4
X_4021_ _2006_ vssd1 vssd1 vccd1 vccd1 _0473_ sky130_fd_sc_hd__clkbuf_1
XFILLER_0_59_253 vssd1 vssd1 vccd1 vccd1 sky130_fd_sc_hd__decap_6
XFILLER_0_47_415 vssd1 vssd1 vccd1 vccd1 sky130_fd_sc_hd__decap_8
X_4785_ clknet_leaf_47_clk _0553_ vssd1 vssd1 vccd1 vccd1 u_core.u_regfile.rf\[3\]\[18\]
+ sky130_fd_sc_hd__dfxtp_1
XFILLER_0_27_161 vssd1 vssd1 vccd1 vccd1 sky130_fd_sc_hd__fill_1
X_3805_ _1898_ vssd1 vssd1 vccd1 vccd1 _0365_ sky130_fd_sc_hd__clkbuf_1
X_3736_ _1860_ vssd1 vssd1 vccd1 vccd1 _0334_ sky130_fd_sc_hd__clkbuf_1
XFILLER_0_27_172 vssd1 vssd1 vccd1 vccd1 sky130_fd_sc_hd__fill_1
XFILLER_0_55_492 vssd1 vssd1 vccd1 vccd1 sky130_fd_sc_hd__decap_6
X_3667_ net281 vssd1 vssd1 vccd1 vccd1 _1826_ sky130_fd_sc_hd__clkbuf_1
X_3598_ _1794_ _1795_ _1796_ net52 vssd1 vssd1 vccd1 vccd1 _0260_ sky130_fd_sc_hd__o31a_1
X_2618_ _0685_ u_core.u_regfile.rf\[29\]\[5\] _1075_ vssd1 vssd1 vccd1 vccd1 _1076_
+ sky130_fd_sc_hd__a21oi_1
X_2549_ _0872_ _1006_ _0935_ vssd1 vssd1 vccd1 vccd1 _1007_ sky130_fd_sc_hd__nand3_1
X_4219_ _1567_ _1481_ _2109_ vssd1 vssd1 vccd1 vccd1 _0568_ sky130_fd_sc_hd__a21oi_1
XFILLER_0_65_223 vssd1 vssd1 vccd1 vccd1 sky130_fd_sc_hd__fill_1
XFILLER_0_80_204 vssd1 vssd1 vccd1 vccd1 sky130_fd_sc_hd__fill_2
XFILLER_0_65_278 vssd1 vssd1 vccd1 vccd1 sky130_fd_sc_hd__fill_2
XFILLER_0_0_209 vccd1 vssd1 vccd1 vssd1 sky130_ef_sc_hd__decap_12
XFILLER_0_56_29 vccd1 vssd1 vccd1 vssd1 sky130_ef_sc_hd__decap_12
XFILLER_0_56_201 vssd1 vssd1 vccd1 vccd1 sky130_fd_sc_hd__fill_1
XFILLER_0_56_234 vssd1 vssd1 vccd1 vccd1 sky130_fd_sc_hd__fill_1
XFILLER_0_44_429 vssd1 vssd1 vccd1 vccd1 sky130_fd_sc_hd__decap_3
X_4570_ clknet_leaf_37_clk _0371_ vssd1 vssd1 vccd1 vccd1 u_core.u_regfile.rf\[27\]\[4\]
+ sky130_fd_sc_hd__dfxtp_1
X_3521_ _1765_ vssd1 vssd1 vccd1 vccd1 _0214_ sky130_fd_sc_hd__clkbuf_1
X_3452_ _1722_ _1704_ _1723_ vssd1 vssd1 vccd1 vccd1 _0187_ sky130_fd_sc_hd__o21ai_1
X_2403_ _0688_ vssd1 vssd1 vccd1 vccd1 _0861_ sky130_fd_sc_hd__clkbuf_4
X_3383_ _1671_ _1672_ _1673_ net48 vssd1 vssd1 vccd1 vccd1 _0168_ sky130_fd_sc_hd__o31a_1
X_2334_ _0772_ _0774_ _0694_ u_core.u_regfile.rf\[5\]\[28\] _0791_ vssd1 vssd1 vccd1
+ vccd1 _0792_ sky130_fd_sc_hd__o221a_2
X_2265_ _0713_ _0709_ _0722_ vssd1 vssd1 vccd1 vccd1 _0723_ sky130_fd_sc_hd__a21o_4
XFILLER_0_79_315 vssd1 vssd1 vccd1 vccd1 sky130_fd_sc_hd__decap_3
X_2196_ u_timer.count_reg\[9\] _0628_ vssd1 vssd1 vccd1 vccd1 _0655_ sky130_fd_sc_hd__or2_1
X_4004_ net363 vssd1 vssd1 vccd1 vccd1 _1998_ sky130_fd_sc_hd__clkbuf_1
X_4768_ clknet_leaf_37_clk _0536_ vssd1 vssd1 vccd1 vccd1 u_core.u_regfile.rf\[3\]\[1\]
+ sky130_fd_sc_hd__dfxtp_1
X_4699_ clknet_leaf_23_clk _0500_ vssd1 vssd1 vccd1 vccd1 u_core.u_regfile.rf\[25\]\[5\]
+ sky130_fd_sc_hd__dfxtp_1
XFILLER_0_30_112 vssd1 vssd1 vccd1 vccd1 sky130_fd_sc_hd__fill_2
XFILLER_0_43_473 vssd1 vssd1 vccd1 vccd1 sky130_fd_sc_hd__fill_2
X_3719_ net335 vssd1 vssd1 vccd1 vccd1 _1852_ sky130_fd_sc_hd__clkbuf_1
XFILLER_0_11_381 vssd1 vssd1 vccd1 vccd1 sky130_fd_sc_hd__decap_4
Xhold22 u_core.u_regfile.rf\[7\]\[13\] vssd1 vssd1 vccd1 vccd1 net55 sky130_fd_sc_hd__dlygate4sd3_1
Xhold11 u_core.u_regfile.rf\[7\]\[15\] vssd1 vssd1 vccd1 vccd1 net44 sky130_fd_sc_hd__dlygate4sd3_1
Xhold33 u_core.u_regfile.rf\[6\]\[15\] vssd1 vssd1 vccd1 vccd1 net66 sky130_fd_sc_hd__dlygate4sd3_1
Xhold44 u_core.u_regfile.rf\[7\]\[25\] vssd1 vssd1 vccd1 vccd1 net77 sky130_fd_sc_hd__dlygate4sd3_1
Xhold55 u_core.u_regfile.rf\[7\]\[28\] vssd1 vssd1 vccd1 vccd1 net88 sky130_fd_sc_hd__dlygate4sd3_1
Xhold88 u_core.u_regfile.rf\[6\]\[11\] vssd1 vssd1 vccd1 vccd1 net121 sky130_fd_sc_hd__dlygate4sd3_1
Xhold99 u_core.u_regfile.rf\[6\]\[18\] vssd1 vssd1 vccd1 vccd1 net132 sky130_fd_sc_hd__dlygate4sd3_1
Xhold66 u_core.u_regfile.rf\[6\]\[27\] vssd1 vssd1 vccd1 vccd1 net99 sky130_fd_sc_hd__dlygate4sd3_1
Xhold77 u_core.u_regfile.rf\[28\]\[28\] vssd1 vssd1 vccd1 vccd1 net110 sky130_fd_sc_hd__dlygate4sd3_1
XFILLER_0_78_392 vccd1 vssd1 vccd1 vssd1 sky130_ef_sc_hd__decap_12
XFILLER_0_61_281 vssd1 vssd1 vccd1 vccd1 sky130_fd_sc_hd__fill_1
XFILLER_0_21_156 vssd1 vssd1 vccd1 vccd1 sky130_fd_sc_hd__fill_1
XTAP_329 vssd1 vccd1 sky130_fd_sc_hd__tapvpwrvgnd_1
XTAP_318 vssd1 vccd1 sky130_fd_sc_hd__tapvpwrvgnd_1
XTAP_307 vssd1 vccd1 sky130_fd_sc_hd__tapvpwrvgnd_1
XFILLER_0_83_27 vccd1 vssd1 vccd1 vssd1 sky130_ef_sc_hd__decap_12
XFILLER_0_76_329 vssd1 vssd1 vccd1 vccd1 sky130_fd_sc_hd__decap_3
XFILLER_0_29_223 vssd1 vssd1 vccd1 vccd1 sky130_fd_sc_hd__fill_1
X_2952_ _1404_ _1409_ vssd1 vssd1 vccd1 vccd1 _1410_ sky130_fd_sc_hd__nand2_1
XFILLER_0_84_362 vssd1 vssd1 vccd1 vccd1 sky130_fd_sc_hd__fill_2
XFILLER_0_17_407 vssd1 vssd1 vccd1 vccd1 sky130_fd_sc_hd__fill_2
XFILLER_0_44_226 vccd1 vssd1 vccd1 vssd1 sky130_ef_sc_hd__decap_12
X_2883_ _1008_ _1152_ _1340_ vssd1 vssd1 vccd1 vccd1 _1341_ sky130_fd_sc_hd__o21ai_1
X_4622_ clknet_leaf_8_clk _0423_ vssd1 vssd1 vccd1 vccd1 u_core.u_regfile.rf\[1\]\[24\]
+ sky130_fd_sc_hd__dfxtp_1
XFILLER_0_4_345 vssd1 vssd1 vccd1 vccd1 sky130_fd_sc_hd__fill_1
XFILLER_0_40_421 vssd1 vssd1 vccd1 vccd1 sky130_fd_sc_hd__decap_6
X_4553_ clknet_leaf_28_clk _0354_ vssd1 vssd1 vccd1 vccd1 u_core.u_regfile.rf\[28\]\[19\]
+ sky130_fd_sc_hd__dfxtp_1
Xhold514 u_timer.threshold_reg\[22\] vssd1 vssd1 vccd1 vccd1 net547 sky130_fd_sc_hd__dlygate4sd3_1
X_3504_ _1683_ _1413_ _1713_ _1480_ _0576_ vssd1 vssd1 vccd1 vccd1 _1757_ sky130_fd_sc_hd__a41o_1
Xhold503 u_core.u_regfile.rf\[31\]\[17\] vssd1 vssd1 vccd1 vccd1 net536 sky130_fd_sc_hd__dlygate4sd3_1
Xhold525 u_core.u_regfile.rf\[31\]\[5\] vssd1 vssd1 vccd1 vccd1 net558 sky130_fd_sc_hd__dlygate4sd3_1
X_4484_ clknet_leaf_27_clk _0285_ vssd1 vssd1 vccd1 vccd1 u_core.u_regfile.rf\[30\]\[14\]
+ sky130_fd_sc_hd__dfxtp_1
X_3435_ _1421_ _1422_ _1708_ _1710_ _1443_ vssd1 vssd1 vccd1 vccd1 _1711_ sky130_fd_sc_hd__a2111o_1
XTAP_852 vssd1 vccd1 sky130_fd_sc_hd__tapvpwrvgnd_1
XTAP_841 vssd1 vccd1 sky130_fd_sc_hd__tapvpwrvgnd_1
XTAP_830 vssd1 vccd1 sky130_fd_sc_hd__tapvpwrvgnd_1
X_3366_ _1668_ _1669_ _1670_ net98 vssd1 vssd1 vccd1 vccd1 _0154_ sky130_fd_sc_hd__o31a_1
XTAP_885 vssd1 vccd1 sky130_fd_sc_hd__tapvpwrvgnd_1
XTAP_874 vssd1 vccd1 sky130_fd_sc_hd__tapvpwrvgnd_1
XTAP_863 vssd1 vccd1 sky130_fd_sc_hd__tapvpwrvgnd_1
X_3297_ _1639_ vssd1 vssd1 vccd1 vccd1 _0116_ sky130_fd_sc_hd__clkbuf_1
X_2317_ _0772_ _0774_ _0694_ u_core.u_regfile.rf\[5\]\[29\] _0719_ vssd1 vssd1 vccd1
+ vccd1 _0775_ sky130_fd_sc_hd__o221a_1
XTAP_896 vssd1 vccd1 sky130_fd_sc_hd__tapvpwrvgnd_1
XFILLER_0_32_3 vssd1 vssd1 vccd1 vccd1 sky130_fd_sc_hd__decap_8
X_2248_ _0705_ vssd1 vssd1 vccd1 vccd1 _0706_ sky130_fd_sc_hd__buf_4
XFILLER_0_79_134 vssd1 vssd1 vccd1 vccd1 sky130_fd_sc_hd__decap_8
X_2179_ net467 vssd1 vssd1 vccd1 vccd1 _0638_ sky130_fd_sc_hd__inv_2
XFILLER_0_73_93 vssd1 vssd1 vccd1 vccd1 sky130_fd_sc_hd__decap_8
XFILLER_0_63_502 vssd1 vssd1 vccd1 vccd1 sky130_fd_sc_hd__fill_2
XFILLER_0_16_451 vssd1 vssd1 vccd1 vccd1 sky130_fd_sc_hd__decap_3
XFILLER_0_31_454 vssd1 vssd1 vccd1 vccd1 sky130_fd_sc_hd__decap_3
XFILLER_0_58_307 vssd1 vssd1 vccd1 vccd1 sky130_fd_sc_hd__fill_1
XFILLER_0_85_137 vssd1 vssd1 vccd1 vccd1 sky130_fd_sc_hd__decap_3
XPHY_151 vssd1 vssd1 vccd1 vccd1 sky130_fd_sc_hd__decap_3
XPHY_140 vssd1 vssd1 vccd1 vccd1 sky130_fd_sc_hd__decap_3
XPHY_162 vssd1 vssd1 vccd1 vccd1 sky130_fd_sc_hd__decap_3
XFILLER_0_81_376 vssd1 vssd1 vccd1 vccd1 sky130_fd_sc_hd__fill_1
XFILLER_0_78_27 vssd1 vssd1 vccd1 vccd1 sky130_fd_sc_hd__fill_1
XFILLER_0_22_421 vssd1 vssd1 vccd1 vccd1 sky130_fd_sc_hd__fill_2
XFILLER_0_1_337 vccd1 vssd1 vccd1 vssd1 sky130_ef_sc_hd__decap_12
X_3220_ _1611_ vssd1 vssd1 vccd1 vccd1 _0067_ sky130_fd_sc_hd__clkbuf_1
X_3151_ _1565_ u_audio.counter\[3\] _1566_ u_audio.counter\[2\] _1571_ vssd1 vssd1
+ vccd1 vccd1 _1572_ sky130_fd_sc_hd__a221o_1
X_3082_ u_timer.count_reg\[13\] u_timer.count_reg\[12\] _1515_ vssd1 vssd1 vccd1 vccd1
+ _1522_ sky130_fd_sc_hd__and3_1
XFILLER_0_43_52 vssd1 vssd1 vccd1 vccd1 sky130_fd_sc_hd__decap_4
XFILLER_0_57_373 vccd1 vssd1 vccd1 vssd1 sky130_ef_sc_hd__decap_12
X_3984_ net272 vssd1 vssd1 vccd1 vccd1 _1988_ sky130_fd_sc_hd__clkbuf_1
XFILLER_0_72_321 vssd1 vssd1 vccd1 vccd1 sky130_fd_sc_hd__decap_8
X_2935_ _1274_ _1293_ _1297_ vssd1 vssd1 vccd1 vccd1 _1393_ sky130_fd_sc_hd__a21o_1
XFILLER_0_72_365 vccd1 vssd1 vccd1 vssd1 sky130_ef_sc_hd__decap_12
XFILLER_0_72_343 vccd1 vssd1 vccd1 vssd1 sky130_ef_sc_hd__decap_12
X_2866_ _0783_ _0748_ _0751_ u_core.u_regfile.rf\[4\]\[31\] _1323_ vssd1 vssd1 vccd1
+ vccd1 _1324_ sky130_fd_sc_hd__o221a_1
X_4605_ clknet_leaf_46_clk _0406_ vssd1 vssd1 vccd1 vccd1 u_core.u_regfile.rf\[1\]\[7\]
+ sky130_fd_sc_hd__dfxtp_1
Xhold311 u_core.u_regfile.rf\[26\]\[14\] vssd1 vssd1 vccd1 vccd1 net344 sky130_fd_sc_hd__dlygate4sd3_1
XFILLER_0_4_175 vssd1 vssd1 vccd1 vccd1 sky130_fd_sc_hd__decap_8
Xhold300 u_core.u_regfile.rf\[24\]\[18\] vssd1 vssd1 vccd1 vccd1 net333 sky130_fd_sc_hd__dlygate4sd3_1
X_2797_ _0780_ _1253_ _1254_ vssd1 vssd1 vccd1 vccd1 _1255_ sky130_fd_sc_hd__o21ai_1
Xhold333 u_core.u_regfile.rf\[5\]\[14\] vssd1 vssd1 vccd1 vccd1 net366 sky130_fd_sc_hd__dlygate4sd3_1
Xhold344 u_core.u_regfile.rf\[5\]\[19\] vssd1 vssd1 vccd1 vccd1 net377 sky130_fd_sc_hd__dlygate4sd3_1
X_4536_ clknet_leaf_5_clk _0337_ vssd1 vssd1 vccd1 vccd1 u_core.u_regfile.rf\[28\]\[2\]
+ sky130_fd_sc_hd__dfxtp_1
Xhold322 u_core.u_regfile.rf\[25\]\[8\] vssd1 vssd1 vccd1 vccd1 net355 sky130_fd_sc_hd__dlygate4sd3_1
XFILLER_0_7_85 vssd1 vssd1 vccd1 vccd1 sky130_fd_sc_hd__fill_1
X_4467_ clknet_leaf_2_clk _0268_ vssd1 vssd1 vccd1 vccd1 u_core.u_regfile.rf\[7\]\[29\]
+ sky130_fd_sc_hd__dfxtp_1
Xhold355 u_core.u_regfile.rf\[1\]\[25\] vssd1 vssd1 vccd1 vccd1 net388 sky130_fd_sc_hd__dlygate4sd3_1
Xhold366 u_core.u_regfile.rf\[1\]\[26\] vssd1 vssd1 vccd1 vccd1 net399 sky130_fd_sc_hd__dlygate4sd3_1
Xhold377 u_core.u_regfile.rf\[29\]\[30\] vssd1 vssd1 vccd1 vccd1 net410 sky130_fd_sc_hd__dlygate4sd3_1
XFILLER_0_68_71 vssd1 vssd1 vccd1 vccd1 sky130_fd_sc_hd__fill_1
Xhold399 u_core.u_regfile.rf\[1\]\[14\] vssd1 vssd1 vccd1 vccd1 net432 sky130_fd_sc_hd__dlygate4sd3_1
Xhold388 u_core.u_regfile.rf\[4\]\[6\] vssd1 vssd1 vccd1 vccd1 net421 sky130_fd_sc_hd__dlygate4sd3_1
X_4398_ clknet_leaf_3_clk _0209_ vssd1 vssd1 vccd1 vccd1 u_core.u_regfile.rf\[29\]\[2\]
+ sky130_fd_sc_hd__dfxtp_1
X_3418_ u_core.u_regfile.rf\[31\]\[5\] _1483_ _1133_ _1304_ vssd1 vssd1 vccd1 vccd1
+ _1697_ sky130_fd_sc_hd__a2bb2o_1
X_3349_ _1665_ vssd1 vssd1 vccd1 vccd1 _0142_ sky130_fd_sc_hd__clkbuf_1
XTAP_660 vssd1 vccd1 sky130_fd_sc_hd__tapvpwrvgnd_1
XTAP_671 vssd1 vccd1 sky130_fd_sc_hd__tapvpwrvgnd_1
XTAP_682 vssd1 vccd1 sky130_fd_sc_hd__tapvpwrvgnd_1
XTAP_693 vssd1 vccd1 sky130_fd_sc_hd__tapvpwrvgnd_1
XFILLER_0_67_159 vssd1 vssd1 vccd1 vccd1 sky130_fd_sc_hd__fill_2
XFILLER_0_63_321 vccd1 vssd1 vccd1 vssd1 sky130_ef_sc_hd__decap_12
XFILLER_0_75_192 vssd1 vssd1 vccd1 vccd1 sky130_fd_sc_hd__decap_4
XFILLER_0_51_505 vssd1 vssd1 vccd1 vccd1 sky130_fd_sc_hd__decap_4
XFILLER_0_31_251 vccd1 vssd1 vccd1 vssd1 sky130_ef_sc_hd__decap_12
XFILLER_0_64_29 vccd1 vssd1 vccd1 vssd1 sky130_ef_sc_hd__decap_12
X_2720_ _1173_ _1177_ vssd1 vssd1 vccd1 vccd1 _1178_ sky130_fd_sc_hd__xor2_2
XFILLER_0_81_173 vssd1 vssd1 vccd1 vccd1 sky130_fd_sc_hd__fill_1
X_2651_ _0922_ _0761_ u_core.u_regfile.rf\[6\]\[6\] vssd1 vssd1 vccd1 vccd1 _1109_
+ sky130_fd_sc_hd__o21a_1
XFILLER_0_54_365 vssd1 vssd1 vccd1 vccd1 sky130_fd_sc_hd__decap_4
X_2582_ _0866_ u_core.u_regfile.rf\[1\]\[1\] _0857_ _0867_ vssd1 vssd1 vccd1 vccd1
+ _1040_ sky130_fd_sc_hd__a31o_1
XFILLER_0_10_413 vssd1 vssd1 vccd1 vccd1 sky130_fd_sc_hd__fill_1
X_4321_ clknet_leaf_41_clk _0132_ vssd1 vssd1 vccd1 vccd1 u_core.u_regfile.rf\[4\]\[21\]
+ sky130_fd_sc_hd__dfxtp_1
XFILLER_0_22_273 vssd1 vssd1 vccd1 vccd1 sky130_fd_sc_hd__decap_8
X_4252_ clknet_leaf_27_clk _0067_ vssd1 vssd1 vccd1 vccd1 u_core.u_regfile.rf\[31\]\[20\]
+ sky130_fd_sc_hd__dfxtp_2
X_3203_ net523 vssd1 vssd1 vccd1 vccd1 _1603_ sky130_fd_sc_hd__clkbuf_1
X_4183_ _2091_ vssd1 vssd1 vccd1 vccd1 _0550_ sky130_fd_sc_hd__clkbuf_1
X_3134_ u_timer.count_reg\[29\] u_timer.count_reg\[28\] u_timer.count_reg\[27\] _1549_
+ vssd1 vssd1 vccd1 vccd1 _1558_ sky130_fd_sc_hd__and4_1
X_3065_ u_timer.count_reg\[9\] u_timer.count_reg\[8\] _1505_ vssd1 vssd1 vccd1 vccd1
+ _1509_ sky130_fd_sc_hd__and3_1
XFILLER_0_49_137 vssd1 vssd1 vccd1 vccd1 sky130_fd_sc_hd__decap_4
X_3967_ _1979_ vssd1 vssd1 vccd1 vccd1 _0446_ sky130_fd_sc_hd__clkbuf_1
XFILLER_0_64_118 vssd1 vssd1 vccd1 vccd1 sky130_fd_sc_hd__fill_2
XFILLER_0_64_129 vssd1 vssd1 vccd1 vccd1 sky130_fd_sc_hd__fill_2
X_2918_ _1274_ _1293_ _1297_ vssd1 vssd1 vccd1 vccd1 _1376_ sky130_fd_sc_hd__a21oi_1
XFILLER_0_70_83 vssd1 vssd1 vccd1 vccd1 sky130_fd_sc_hd__fill_1
X_3898_ net445 vssd1 vssd1 vccd1 vccd1 _1945_ sky130_fd_sc_hd__clkbuf_1
XFILLER_0_5_440 vssd1 vssd1 vccd1 vccd1 sky130_fd_sc_hd__decap_8
Xclkbuf_leaf_30_clk clknet_2_1__leaf_clk vssd1 vssd1 vccd1 vccd1 clknet_leaf_30_clk
+ sky130_fd_sc_hd__clkbuf_16
X_2849_ _0783_ _0748_ _0751_ u_core.u_regfile.rf\[4\]\[30\] _1306_ vssd1 vssd1 vccd1
+ vccd1 _1307_ sky130_fd_sc_hd__o221a_1
XFILLER_0_79_81 vccd1 vssd1 vccd1 vssd1 sky130_ef_sc_hd__decap_12
XFILLER_0_5_484 vccd1 vssd1 vccd1 vssd1 sky130_ef_sc_hd__decap_12
XFILLER_0_60_368 vssd1 vssd1 vccd1 vccd1 sky130_fd_sc_hd__fill_1
Xhold152 u_core.u_regfile.rf\[26\]\[16\] vssd1 vssd1 vccd1 vccd1 net185 sky130_fd_sc_hd__dlygate4sd3_1
X_4519_ clknet_leaf_38_clk _0320_ vssd1 vssd1 vccd1 vccd1 u_core.u_regfile.rf\[2\]\[17\]
+ sky130_fd_sc_hd__dfxtp_1
Xhold141 u_core.u_regfile.rf\[25\]\[9\] vssd1 vssd1 vccd1 vccd1 net174 sky130_fd_sc_hd__dlygate4sd3_1
Xhold130 u_core.u_regfile.rf\[27\]\[10\] vssd1 vssd1 vccd1 vccd1 net163 sky130_fd_sc_hd__dlygate4sd3_1
Xhold174 u_core.u_regfile.rf\[2\]\[4\] vssd1 vssd1 vccd1 vccd1 net207 sky130_fd_sc_hd__dlygate4sd3_1
Xhold163 u_core.u_regfile.rf\[2\]\[22\] vssd1 vssd1 vccd1 vccd1 net196 sky130_fd_sc_hd__dlygate4sd3_1
Xhold185 u_core.u_regfile.rf\[26\]\[7\] vssd1 vssd1 vccd1 vccd1 net218 sky130_fd_sc_hd__dlygate4sd3_1
Xhold196 u_core.u_regfile.rf\[30\]\[19\] vssd1 vssd1 vccd1 vccd1 net229 sky130_fd_sc_hd__dlygate4sd3_1
XTAP_490 vssd1 vccd1 sky130_fd_sc_hd__tapvpwrvgnd_1
XFILLER_0_68_402 vccd1 vssd1 vccd1 vssd1 sky130_ef_sc_hd__decap_12
XFILLER_0_68_446 vssd1 vssd1 vccd1 vccd1 sky130_fd_sc_hd__fill_1
XFILLER_0_83_405 vccd1 vssd1 vccd1 vssd1 sky130_ef_sc_hd__decap_12
XFILLER_0_83_449 vccd1 vssd1 vccd1 vssd1 sky130_ef_sc_hd__decap_12
XFILLER_0_36_343 vssd1 vssd1 vccd1 vccd1 sky130_fd_sc_hd__fill_1
Xclkbuf_leaf_21_clk clknet_2_3__leaf_clk vssd1 vssd1 vccd1 vccd1 clknet_leaf_21_clk
+ sky130_fd_sc_hd__clkbuf_16
XFILLER_0_63_162 vssd1 vssd1 vccd1 vccd1 sky130_fd_sc_hd__decap_6
XFILLER_0_75_39 vccd1 vssd1 vccd1 vssd1 sky130_ef_sc_hd__decap_12
XFILLER_0_24_65 vssd1 vssd1 vccd1 vccd1 sky130_fd_sc_hd__fill_1
XFILLER_0_74_427 vssd1 vssd1 vccd1 vccd1 sky130_fd_sc_hd__fill_1
X_3821_ _1906_ vssd1 vssd1 vccd1 vccd1 _0373_ sky130_fd_sc_hd__clkbuf_1
XFILLER_0_39_181 vssd1 vssd1 vccd1 vccd1 sky130_fd_sc_hd__fill_1
Xclkbuf_leaf_12_clk clknet_2_2__leaf_clk vssd1 vssd1 vccd1 vccd1 clknet_leaf_12_clk
+ sky130_fd_sc_hd__clkbuf_16
XFILLER_0_6_237 vccd1 vssd1 vccd1 vssd1 sky130_ef_sc_hd__decap_12
X_3752_ _1421_ _1422_ vssd1 vssd1 vccd1 vccd1 _1870_ sky130_fd_sc_hd__and2_1
XFILLER_0_54_162 vssd1 vssd1 vccd1 vccd1 sky130_fd_sc_hd__fill_2
X_3683_ net171 vssd1 vssd1 vccd1 vccd1 _1834_ sky130_fd_sc_hd__clkbuf_1
X_2703_ _0952_ _1159_ _0702_ _0909_ _1160_ vssd1 vssd1 vccd1 vccd1 _1161_ sky130_fd_sc_hd__a221o_1
XFILLER_0_2_421 vccd1 vssd1 vccd1 vssd1 sky130_ef_sc_hd__decap_12
XFILLER_0_30_508 vssd1 vssd1 vccd1 vccd1 sky130_fd_sc_hd__fill_2
X_2634_ u_core.u_regfile.rf\[1\]\[4\] _0742_ _0731_ _0709_ vssd1 vssd1 vccd1 vccd1
+ _1092_ sky130_fd_sc_hd__o2bb2a_1
X_2565_ u_core.u_regfile.rf\[4\]\[0\] _0750_ _0812_ vssd1 vssd1 vccd1 vccd1 _1023_
+ sky130_fd_sc_hd__o21ai_1
X_4304_ clknet_leaf_48_clk _0115_ vssd1 vssd1 vccd1 vccd1 u_core.u_regfile.rf\[4\]\[4\]
+ sky130_fd_sc_hd__dfxtp_1
XFILLER_0_10_276 vccd1 vssd1 vccd1 vssd1 sky130_ef_sc_hd__decap_12
X_2496_ _0686_ vssd1 vssd1 vccd1 vccd1 _0954_ sky130_fd_sc_hd__buf_4
X_4235_ clknet_leaf_8_clk _0050_ vssd1 vssd1 vccd1 vccd1 u_core.u_regfile.rf\[31\]\[3\]
+ sky130_fd_sc_hd__dfxtp_1
X_4166_ net262 vssd1 vssd1 vccd1 vccd1 _2083_ sky130_fd_sc_hd__clkbuf_1
X_3117_ net527 _1544_ _1545_ vssd1 vssd1 vccd1 vccd1 _0023_ sky130_fd_sc_hd__a21oi_1
X_4097_ _2044_ vssd1 vssd1 vccd1 vccd1 _0511_ sky130_fd_sc_hd__clkbuf_1
X_3048_ _1497_ vssd1 vssd1 vccd1 vccd1 _0032_ sky130_fd_sc_hd__clkbuf_1
XFILLER_0_81_93 vssd1 vssd1 vccd1 vccd1 sky130_fd_sc_hd__decap_6
XFILLER_0_77_298 vccd1 vssd1 vccd1 vssd1 sky130_ef_sc_hd__decap_12
XFILLER_0_80_419 vssd1 vssd1 vccd1 vccd1 sky130_fd_sc_hd__fill_1
XFILLER_0_33_313 vssd1 vssd1 vccd1 vccd1 sky130_fd_sc_hd__decap_8
XFILLER_0_73_482 vccd1 vssd1 vccd1 vssd1 sky130_ef_sc_hd__decap_12
XFILLER_0_5_281 vssd1 vssd1 vccd1 vccd1 sky130_fd_sc_hd__decap_8
XFILLER_0_41_390 vssd1 vssd1 vccd1 vccd1 sky130_fd_sc_hd__fill_2
XFILLER_0_83_279 vssd1 vssd1 vccd1 vccd1 sky130_fd_sc_hd__fill_1
XFILLER_0_36_151 vssd1 vssd1 vccd1 vccd1 sky130_fd_sc_hd__fill_1
X_2350_ _0757_ vssd1 vssd1 vccd1 vccd1 _0808_ sky130_fd_sc_hd__clkbuf_4
X_2281_ _0711_ _0737_ _0738_ vssd1 vssd1 vccd1 vccd1 _0739_ sky130_fd_sc_hd__o21ai_4
X_4020_ net145 vssd1 vssd1 vccd1 vccd1 _2006_ sky130_fd_sc_hd__clkbuf_1
Xclkbuf_leaf_1_clk clknet_2_0__leaf_clk vssd1 vssd1 vccd1 vccd1 clknet_leaf_1_clk
+ sky130_fd_sc_hd__clkbuf_16
XFILLER_0_29_9 vssd1 vssd1 vccd1 vccd1 sky130_fd_sc_hd__decap_3
XFILLER_0_59_243 vssd1 vssd1 vccd1 vccd1 sky130_fd_sc_hd__fill_1
XFILLER_0_7_502 vssd1 vssd1 vccd1 vccd1 sky130_fd_sc_hd__fill_2
X_4784_ clknet_leaf_34_clk _0552_ vssd1 vssd1 vccd1 vccd1 u_core.u_regfile.rf\[3\]\[17\]
+ sky130_fd_sc_hd__dfxtp_1
X_3804_ _1684_ net529 _1868_ vssd1 vssd1 vccd1 vccd1 _1898_ sky130_fd_sc_hd__mux2_1
XFILLER_0_62_419 vssd1 vssd1 vccd1 vccd1 sky130_fd_sc_hd__fill_1
X_3735_ net233 vssd1 vssd1 vccd1 vccd1 _1860_ sky130_fd_sc_hd__clkbuf_1
XFILLER_0_70_441 vssd1 vssd1 vccd1 vccd1 sky130_fd_sc_hd__fill_1
X_3666_ _1825_ vssd1 vssd1 vccd1 vccd1 _0299_ sky130_fd_sc_hd__clkbuf_1
XFILLER_0_2_251 vssd1 vssd1 vccd1 vccd1 sky130_fd_sc_hd__fill_1
X_3597_ _1794_ _1795_ _1796_ net75 vssd1 vssd1 vccd1 vccd1 _0259_ sky130_fd_sc_hd__o31a_1
X_2617_ _0704_ u_core.u_regfile.rf\[31\]\[5\] vssd1 vssd1 vccd1 vccd1 _1075_ sky130_fd_sc_hd__and2_1
XFILLER_0_62_3 vccd1 vssd1 vccd1 vssd1 sky130_ef_sc_hd__decap_12
X_2548_ _1003_ _1004_ _0871_ _1005_ vssd1 vssd1 vccd1 vccd1 _1006_ sky130_fd_sc_hd__o211ai_1
X_2479_ u_core.u_regfile.rf\[6\]\[9\] vssd1 vssd1 vccd1 vccd1 _0937_ sky130_fd_sc_hd__inv_2
X_4218_ _1688_ _1689_ net12 _1694_ _1695_ vssd1 vssd1 vccd1 vccd1 _2109_ sky130_fd_sc_hd__o2111a_1
X_4149_ net497 _2062_ _2074_ _2061_ vssd1 vssd1 vccd1 vccd1 _0533_ sky130_fd_sc_hd__o2bb2ai_1
XFILLER_0_73_290 vccd1 vssd1 vccd1 vssd1 sky130_ef_sc_hd__decap_12
XFILLER_0_18_184 vssd1 vssd1 vccd1 vccd1 sky130_fd_sc_hd__fill_1
XFILLER_0_33_132 vssd1 vssd1 vccd1 vccd1 sky130_fd_sc_hd__decap_4
XFILLER_0_72_29 vccd1 vssd1 vccd1 vssd1 sky130_ef_sc_hd__decap_12
XFILLER_0_44_419 vssd1 vssd1 vccd1 vccd1 sky130_fd_sc_hd__fill_1
XFILLER_0_21_55 vssd1 vssd1 vccd1 vccd1 sky130_fd_sc_hd__fill_1
X_3520_ net400 vssd1 vssd1 vccd1 vccd1 _1765_ sky130_fd_sc_hd__clkbuf_1
X_3451_ _1705_ _1706_ _1714_ _1715_ _0625_ vssd1 vssd1 vccd1 vccd1 _1723_ sky130_fd_sc_hd__a41o_1
X_2402_ _0753_ vssd1 vssd1 vccd1 vccd1 _0860_ sky130_fd_sc_hd__buf_2
X_3382_ _1671_ _1672_ _1673_ net103 vssd1 vssd1 vccd1 vccd1 _0167_ sky130_fd_sc_hd__o31a_1
XFILLER_0_20_382 vssd1 vssd1 vccd1 vccd1 sky130_fd_sc_hd__fill_2
X_2333_ u_core.u_regfile.rf\[28\]\[28\] _0698_ _0701_ _0703_ _0790_ vssd1 vssd1 vccd1
+ vccd1 _0791_ sky130_fd_sc_hd__a221o_1
X_2264_ _0688_ _0695_ _0720_ _0721_ vssd1 vssd1 vccd1 vccd1 _0722_ sky130_fd_sc_hd__o22a_4
X_2195_ u_timer.count_reg\[15\] _0612_ vssd1 vssd1 vccd1 vccd1 _0654_ sky130_fd_sc_hd__nor2_1
X_4003_ _1997_ vssd1 vssd1 vccd1 vccd1 _0464_ sky130_fd_sc_hd__clkbuf_1
XFILLER_0_46_85 vssd1 vssd1 vccd1 vccd1 sky130_fd_sc_hd__fill_1
XFILLER_0_62_73 vssd1 vssd1 vccd1 vccd1 sky130_fd_sc_hd__decap_6
XFILLER_0_47_279 vssd1 vssd1 vccd1 vccd1 sky130_fd_sc_hd__fill_1
XFILLER_0_28_493 vccd1 vssd1 vccd1 vssd1 sky130_ef_sc_hd__decap_12
X_4767_ clknet_leaf_39_clk _0535_ vssd1 vssd1 vccd1 vccd1 u_core.u_regfile.rf\[3\]\[0\]
+ sky130_fd_sc_hd__dfxtp_1
XFILLER_0_43_441 vssd1 vssd1 vccd1 vccd1 sky130_fd_sc_hd__decap_6
X_3718_ _1851_ vssd1 vssd1 vccd1 vccd1 _0325_ sky130_fd_sc_hd__clkbuf_1
X_4698_ clknet_leaf_38_clk _0499_ vssd1 vssd1 vccd1 vccd1 u_core.u_regfile.rf\[25\]\[4\]
+ sky130_fd_sc_hd__dfxtp_1
X_3649_ net208 vssd1 vssd1 vccd1 vccd1 _1817_ sky130_fd_sc_hd__clkbuf_1
Xhold12 u_core.u_regfile.rf\[7\]\[16\] vssd1 vssd1 vccd1 vccd1 net45 sky130_fd_sc_hd__dlygate4sd3_1
Xhold23 u_core.u_regfile.rf\[5\]\[5\] vssd1 vssd1 vccd1 vccd1 net56 sky130_fd_sc_hd__dlygate4sd3_1
Xhold45 u_core.u_regfile.rf\[7\]\[17\] vssd1 vssd1 vccd1 vccd1 net78 sky130_fd_sc_hd__dlygate4sd3_1
Xhold56 u_core.u_regfile.rf\[6\]\[12\] vssd1 vssd1 vccd1 vccd1 net89 sky130_fd_sc_hd__dlygate4sd3_1
Xhold34 u_core.u_regfile.rf\[28\]\[18\] vssd1 vssd1 vccd1 vccd1 net67 sky130_fd_sc_hd__dlygate4sd3_1
Xhold67 u_core.u_regfile.rf\[7\]\[7\] vssd1 vssd1 vccd1 vccd1 net100 sky130_fd_sc_hd__dlygate4sd3_1
Xhold78 u_core.u_regfile.rf\[7\]\[4\] vssd1 vssd1 vccd1 vccd1 net111 sky130_fd_sc_hd__dlygate4sd3_1
Xhold89 u_core.u_regfile.rf\[5\]\[29\] vssd1 vssd1 vccd1 vccd1 net122 sky130_fd_sc_hd__dlygate4sd3_1
XFILLER_0_81_503 vssd1 vssd1 vccd1 vccd1 sky130_fd_sc_hd__fill_1
XFILLER_0_19_460 vccd1 vssd1 vccd1 vssd1 sky130_ef_sc_hd__decap_12
XFILLER_0_26_419 vssd1 vssd1 vccd1 vccd1 sky130_fd_sc_hd__fill_1
XFILLER_0_21_113 vssd1 vssd1 vccd1 vccd1 sky130_fd_sc_hd__fill_1
XTAP_319 vssd1 vccd1 sky130_fd_sc_hd__tapvpwrvgnd_1
XTAP_308 vssd1 vccd1 sky130_fd_sc_hd__tapvpwrvgnd_1
XFILLER_0_83_39 vccd1 vssd1 vccd1 vssd1 sky130_ef_sc_hd__decap_12
XFILLER_0_84_330 vccd1 vssd1 vccd1 vssd1 sky130_ef_sc_hd__decap_12
X_2951_ _0793_ _1301_ _1407_ _1408_ vssd1 vssd1 vccd1 vccd1 _1409_ sky130_fd_sc_hd__o2bb2ai_1
X_4621_ clknet_leaf_41_clk _0422_ vssd1 vssd1 vccd1 vccd1 u_core.u_regfile.rf\[1\]\[23\]
+ sky130_fd_sc_hd__dfxtp_1
XFILLER_0_32_98 vssd1 vssd1 vccd1 vccd1 sky130_fd_sc_hd__decap_6
XFILLER_0_44_238 vssd1 vssd1 vccd1 vccd1 sky130_fd_sc_hd__fill_1
X_2882_ _1209_ vssd1 vssd1 vccd1 vccd1 _1340_ sky130_fd_sc_hd__inv_2
XFILLER_0_4_302 vssd1 vssd1 vccd1 vccd1 sky130_fd_sc_hd__decap_6
X_4552_ clknet_leaf_30_clk _0353_ vssd1 vssd1 vccd1 vccd1 u_core.u_regfile.rf\[28\]\[18\]
+ sky130_fd_sc_hd__dfxtp_1
Xhold515 u_timer.threshold_reg\[31\] vssd1 vssd1 vccd1 vccd1 net548 sky130_fd_sc_hd__dlygate4sd3_1
X_3503_ _1308_ _1680_ _1756_ vssd1 vssd1 vccd1 vccd1 _0205_ sky130_fd_sc_hd__o21ai_1
Xhold504 u_core.u_regfile.rf\[4\]\[4\] vssd1 vssd1 vccd1 vccd1 net537 sky130_fd_sc_hd__dlygate4sd3_1
Xhold526 u_core.u_regfile.rf\[31\]\[19\] vssd1 vssd1 vccd1 vccd1 net559 sky130_fd_sc_hd__dlygate4sd3_1
X_4483_ clknet_leaf_24_clk _0284_ vssd1 vssd1 vccd1 vccd1 u_core.u_regfile.rf\[30\]\[13\]
+ sky130_fd_sc_hd__dfxtp_1
XFILLER_0_40_455 vssd1 vssd1 vccd1 vccd1 sky130_fd_sc_hd__fill_1
X_3434_ _1709_ _1434_ vssd1 vssd1 vccd1 vccd1 _1710_ sky130_fd_sc_hd__nand2_1
XTAP_853 vssd1 vccd1 sky130_fd_sc_hd__tapvpwrvgnd_1
XTAP_842 vssd1 vccd1 sky130_fd_sc_hd__tapvpwrvgnd_1
XTAP_831 vssd1 vccd1 sky130_fd_sc_hd__tapvpwrvgnd_1
XTAP_820 vssd1 vccd1 sky130_fd_sc_hd__tapvpwrvgnd_1
X_3365_ _1668_ _1669_ _1670_ net370 vssd1 vssd1 vccd1 vccd1 _0153_ sky130_fd_sc_hd__o31a_1
XFILLER_0_57_51 vssd1 vssd1 vccd1 vccd1 sky130_fd_sc_hd__decap_4
XTAP_886 vssd1 vccd1 sky130_fd_sc_hd__tapvpwrvgnd_1
XTAP_875 vssd1 vccd1 sky130_fd_sc_hd__tapvpwrvgnd_1
XTAP_864 vssd1 vccd1 sky130_fd_sc_hd__tapvpwrvgnd_1
X_3296_ net470 vssd1 vssd1 vccd1 vccd1 _1639_ sky130_fd_sc_hd__clkbuf_1
X_2316_ _0773_ vssd1 vssd1 vccd1 vccd1 _0774_ sky130_fd_sc_hd__buf_4
XTAP_897 vssd1 vccd1 sky130_fd_sc_hd__tapvpwrvgnd_1
X_2247_ _0704_ vssd1 vssd1 vccd1 vccd1 _0705_ sky130_fd_sc_hd__buf_4
XFILLER_0_25_3 vssd1 vssd1 vccd1 vccd1 sky130_fd_sc_hd__fill_1
XFILLER_0_79_146 vccd1 vssd1 vccd1 vssd1 sky130_ef_sc_hd__decap_12
X_2178_ net495 vssd1 vssd1 vccd1 vccd1 _0637_ sky130_fd_sc_hd__inv_2
XFILLER_0_75_374 vssd1 vssd1 vccd1 vccd1 sky130_fd_sc_hd__fill_2
XFILLER_0_35_238 vccd1 vssd1 vccd1 vssd1 sky130_ef_sc_hd__decap_12
XFILLER_0_16_485 vssd1 vssd1 vccd1 vccd1 sky130_fd_sc_hd__decap_3
XPHY_152 vssd1 vssd1 vccd1 vccd1 sky130_fd_sc_hd__decap_3
XPHY_141 vssd1 vssd1 vccd1 vccd1 sky130_fd_sc_hd__decap_3
XPHY_130 vssd1 vssd1 vccd1 vccd1 sky130_fd_sc_hd__decap_3
XPHY_163 vssd1 vssd1 vccd1 vccd1 sky130_fd_sc_hd__decap_3
XFILLER_0_81_311 vssd1 vssd1 vccd1 vccd1 sky130_fd_sc_hd__fill_1
XFILLER_0_1_305 vccd1 vssd1 vccd1 vssd1 sky130_ef_sc_hd__decap_12
XFILLER_0_1_349 vccd1 vssd1 vccd1 vssd1 sky130_ef_sc_hd__decap_12
XFILLER_0_22_466 vssd1 vssd1 vccd1 vccd1 sky130_fd_sc_hd__fill_2
XFILLER_0_22_477 vccd1 vssd1 vccd1 vssd1 sky130_ef_sc_hd__decap_12
X_3150_ u_audio.counter\[2\] _1566_ _1568_ _1570_ vssd1 vssd1 vccd1 vccd1 _1571_ sky130_fd_sc_hd__o22a_1
X_3081_ _1521_ vssd1 vssd1 vccd1 vccd1 _0010_ sky130_fd_sc_hd__clkbuf_1
XFILLER_0_49_319 vssd1 vssd1 vccd1 vccd1 sky130_fd_sc_hd__decap_4
X_3983_ _1987_ vssd1 vssd1 vccd1 vccd1 _0454_ sky130_fd_sc_hd__clkbuf_1
XFILLER_0_45_503 vssd1 vssd1 vccd1 vccd1 sky130_fd_sc_hd__fill_1
X_2934_ _1363_ _1390_ _1391_ _1353_ vssd1 vssd1 vccd1 vccd1 _1392_ sky130_fd_sc_hd__a22oi_1
XFILLER_0_57_385 vssd1 vssd1 vccd1 vccd1 sky130_fd_sc_hd__decap_4
XFILLER_0_72_355 vssd1 vssd1 vccd1 vccd1 sky130_fd_sc_hd__decap_8
X_2865_ _0717_ u_core.u_regfile.rf\[7\]\[31\] _0754_ _0756_ _1322_ vssd1 vssd1 vccd1
+ vccd1 _1323_ sky130_fd_sc_hd__a311o_1
XFILLER_0_60_506 vssd1 vssd1 vccd1 vccd1 sky130_fd_sc_hd__decap_4
X_4604_ clknet_leaf_3_clk _0405_ vssd1 vssd1 vccd1 vccd1 u_core.u_regfile.rf\[1\]\[6\]
+ sky130_fd_sc_hd__dfxtp_1
Xhold301 u_core.u_regfile.rf\[30\]\[8\] vssd1 vssd1 vccd1 vccd1 net334 sky130_fd_sc_hd__dlygate4sd3_1
X_4535_ clknet_leaf_5_clk _0336_ vssd1 vssd1 vccd1 vccd1 u_core.u_regfile.rf\[28\]\[1\]
+ sky130_fd_sc_hd__dfxtp_1
X_2796_ _0771_ _0774_ _0694_ u_core.u_regfile.rf\[5\]\[23\] _1249_ vssd1 vssd1 vccd1
+ vccd1 _1254_ sky130_fd_sc_hd__o221a_1
Xhold312 u_timer.threshold_reg\[6\] vssd1 vssd1 vccd1 vccd1 net345 sky130_fd_sc_hd__dlygate4sd3_1
Xhold323 u_core.u_regfile.rf\[27\]\[4\] vssd1 vssd1 vccd1 vccd1 net356 sky130_fd_sc_hd__dlygate4sd3_1
Xhold334 u_core.u_regfile.rf\[25\]\[13\] vssd1 vssd1 vccd1 vccd1 net367 sky130_fd_sc_hd__dlygate4sd3_1
XFILLER_0_13_488 vssd1 vssd1 vccd1 vccd1 sky130_fd_sc_hd__decap_8
Xhold345 u_core.u_regfile.rf\[1\]\[11\] vssd1 vssd1 vccd1 vccd1 net378 sky130_fd_sc_hd__dlygate4sd3_1
X_4466_ clknet_leaf_2_clk _0267_ vssd1 vssd1 vccd1 vccd1 u_core.u_regfile.rf\[7\]\[28\]
+ sky130_fd_sc_hd__dfxtp_1
Xhold367 u_core.u_regfile.rf\[29\]\[7\] vssd1 vssd1 vccd1 vccd1 net400 sky130_fd_sc_hd__dlygate4sd3_1
Xhold356 u_core.u_regfile.rf\[29\]\[27\] vssd1 vssd1 vccd1 vccd1 net389 sky130_fd_sc_hd__dlygate4sd3_1
Xhold378 u_core.u_regfile.rf\[29\]\[31\] vssd1 vssd1 vccd1 vccd1 net411 sky130_fd_sc_hd__dlygate4sd3_1
X_3417_ _0638_ _1680_ _1696_ vssd1 vssd1 vccd1 vccd1 _0179_ sky130_fd_sc_hd__a21oi_1
Xhold389 u_core.u_regfile.rf\[1\]\[18\] vssd1 vssd1 vccd1 vccd1 net422 sky130_fd_sc_hd__dlygate4sd3_1
X_4397_ clknet_leaf_3_clk _0208_ vssd1 vssd1 vccd1 vccd1 u_core.u_regfile.rf\[29\]\[1\]
+ sky130_fd_sc_hd__dfxtp_1
XFILLER_0_0_393 vccd1 vssd1 vccd1 vssd1 sky130_ef_sc_hd__decap_12
X_3348_ net439 vssd1 vssd1 vccd1 vccd1 _1665_ sky130_fd_sc_hd__clkbuf_1
XTAP_650 vssd1 vccd1 sky130_fd_sc_hd__tapvpwrvgnd_1
XTAP_661 vssd1 vccd1 sky130_fd_sc_hd__tapvpwrvgnd_1
XTAP_672 vssd1 vccd1 sky130_fd_sc_hd__tapvpwrvgnd_1
XTAP_683 vssd1 vccd1 sky130_fd_sc_hd__tapvpwrvgnd_1
XTAP_694 vssd1 vccd1 sky130_fd_sc_hd__tapvpwrvgnd_1
X_3279_ _1629_ _1630_ _1631_ net99 vssd1 vssd1 vccd1 vccd1 _0106_ sky130_fd_sc_hd__o31a_1
XFILLER_0_67_127 vssd1 vssd1 vccd1 vccd1 sky130_fd_sc_hd__fill_1
XFILLER_0_48_330 vccd1 vssd1 vccd1 vssd1 sky130_ef_sc_hd__decap_12
XFILLER_0_63_333 vssd1 vssd1 vccd1 vccd1 sky130_fd_sc_hd__decap_3
XFILLER_0_63_366 vssd1 vssd1 vccd1 vccd1 sky130_fd_sc_hd__fill_1
XFILLER_0_31_263 vccd1 vssd1 vccd1 vssd1 sky130_ef_sc_hd__decap_12
XFILLER_0_58_105 vssd1 vssd1 vccd1 vccd1 sky130_fd_sc_hd__fill_1
XFILLER_0_80_29 vccd1 vssd1 vccd1 vssd1 sky130_ef_sc_hd__decap_12
XFILLER_0_58_127 vssd1 vssd1 vccd1 vccd1 sky130_fd_sc_hd__fill_1
XFILLER_0_39_374 vssd1 vssd1 vccd1 vccd1 sky130_fd_sc_hd__fill_1
XFILLER_0_39_396 vssd1 vssd1 vccd1 vccd1 sky130_fd_sc_hd__fill_1
X_2650_ _0840_ _0720_ _0740_ _0861_ u_core.u_regfile.rf\[7\]\[6\] vssd1 vssd1 vccd1
+ vccd1 _1108_ sky130_fd_sc_hd__o311a_1
X_2581_ _1036_ _1038_ _0755_ vssd1 vssd1 vccd1 vccd1 _1039_ sky130_fd_sc_hd__a21oi_2
XFILLER_0_1_113 vccd1 vssd1 vccd1 vssd1 sky130_ef_sc_hd__decap_12
X_4320_ clknet_leaf_46_clk _0131_ vssd1 vssd1 vccd1 vccd1 u_core.u_regfile.rf\[4\]\[20\]
+ sky130_fd_sc_hd__dfxtp_1
XFILLER_0_22_296 vssd1 vssd1 vccd1 vccd1 sky130_fd_sc_hd__fill_2
X_4251_ clknet_leaf_29_clk _0066_ vssd1 vssd1 vccd1 vccd1 u_core.u_regfile.rf\[31\]\[19\]
+ sky130_fd_sc_hd__dfxtp_2
X_3202_ _1602_ vssd1 vssd1 vccd1 vccd1 _0058_ sky130_fd_sc_hd__clkbuf_1
X_4182_ net179 vssd1 vssd1 vccd1 vccd1 _2091_ sky130_fd_sc_hd__clkbuf_1
X_3133_ _1557_ vssd1 vssd1 vccd1 vccd1 _0027_ sky130_fd_sc_hd__clkbuf_1
X_3064_ net533 _1505_ _1508_ _0001_ vssd1 vssd1 vccd1 vccd1 _0037_ sky130_fd_sc_hd__a211oi_1
XFILLER_0_54_41 vssd1 vssd1 vccd1 vccd1 sky130_fd_sc_hd__decap_6
XFILLER_0_77_447 vssd1 vssd1 vccd1 vccd1 sky130_fd_sc_hd__fill_1
XFILLER_0_54_85 vssd1 vssd1 vccd1 vccd1 sky130_fd_sc_hd__fill_2
X_3966_ net290 vssd1 vssd1 vccd1 vccd1 _1979_ sky130_fd_sc_hd__clkbuf_1
XFILLER_0_9_279 vssd1 vssd1 vccd1 vccd1 sky130_fd_sc_hd__fill_1
X_2917_ _1336_ _1374_ vssd1 vssd1 vccd1 vccd1 _1375_ sky130_fd_sc_hd__nand2_1
X_3897_ _1944_ vssd1 vssd1 vccd1 vccd1 _0411_ sky130_fd_sc_hd__clkbuf_1
X_2848_ _0717_ u_core.u_regfile.rf\[7\]\[30\] _0754_ _0756_ _1305_ vssd1 vssd1 vccd1
+ vccd1 _1306_ sky130_fd_sc_hd__a311o_1
XFILLER_0_5_496 vssd1 vssd1 vccd1 vccd1 sky130_fd_sc_hd__decap_8
X_2779_ _0736_ _1235_ _1225_ _1231_ vssd1 vssd1 vccd1 vccd1 _1237_ sky130_fd_sc_hd__nand4_2
XFILLER_0_79_93 vccd1 vssd1 vccd1 vssd1 sky130_ef_sc_hd__decap_12
Xhold120 u_core.u_regfile.rf\[24\]\[25\] vssd1 vssd1 vccd1 vccd1 net153 sky130_fd_sc_hd__dlygate4sd3_1
X_4518_ clknet_leaf_40_clk _0319_ vssd1 vssd1 vccd1 vccd1 u_core.u_regfile.rf\[2\]\[16\]
+ sky130_fd_sc_hd__dfxtp_1
Xhold131 u_core.u_regfile.rf\[27\]\[11\] vssd1 vssd1 vccd1 vccd1 net164 sky130_fd_sc_hd__dlygate4sd3_1
Xhold153 u_core.u_regfile.rf\[24\]\[21\] vssd1 vssd1 vccd1 vccd1 net186 sky130_fd_sc_hd__dlygate4sd3_1
Xhold142 u_core.u_regfile.rf\[24\]\[12\] vssd1 vssd1 vccd1 vccd1 net175 sky130_fd_sc_hd__dlygate4sd3_1
Xhold186 u_timer.threshold_reg\[2\] vssd1 vssd1 vccd1 vccd1 net219 sky130_fd_sc_hd__dlygate4sd3_1
X_4449_ clknet_leaf_48_clk _0250_ vssd1 vssd1 vccd1 vccd1 u_core.u_regfile.rf\[7\]\[11\]
+ sky130_fd_sc_hd__dfxtp_1
XFILLER_0_0_9 vccd1 vssd1 vccd1 vssd1 sky130_ef_sc_hd__decap_12
Xhold175 u_core.u_regfile.rf\[30\]\[20\] vssd1 vssd1 vccd1 vccd1 net208 sky130_fd_sc_hd__dlygate4sd3_1
Xhold164 u_core.u_regfile.rf\[30\]\[30\] vssd1 vssd1 vccd1 vccd1 net197 sky130_fd_sc_hd__dlygate4sd3_1
Xhold197 u_core.u_regfile.rf\[26\]\[19\] vssd1 vssd1 vccd1 vccd1 net230 sky130_fd_sc_hd__dlygate4sd3_1
XTAP_480 vssd1 vccd1 sky130_fd_sc_hd__tapvpwrvgnd_1
XTAP_491 vssd1 vccd1 sky130_fd_sc_hd__tapvpwrvgnd_1
XFILLER_0_68_414 vssd1 vssd1 vccd1 vccd1 sky130_fd_sc_hd__fill_2
XFILLER_0_68_458 vccd1 vssd1 vccd1 vssd1 sky130_ef_sc_hd__decap_12
XFILLER_0_83_417 vccd1 vssd1 vccd1 vssd1 sky130_ef_sc_hd__decap_12
XFILLER_0_24_506 vssd1 vssd1 vccd1 vccd1 sky130_fd_sc_hd__decap_4
XFILLER_0_51_303 vssd1 vssd1 vccd1 vccd1 sky130_fd_sc_hd__fill_1
XFILLER_0_51_358 vssd1 vssd1 vccd1 vccd1 sky130_fd_sc_hd__fill_1
X_3820_ net158 vssd1 vssd1 vccd1 vccd1 _1906_ sky130_fd_sc_hd__clkbuf_1
XFILLER_0_46_119 vssd1 vssd1 vccd1 vccd1 sky130_fd_sc_hd__fill_1
X_3751_ _1869_ vssd1 vssd1 vccd1 vccd1 _0340_ sky130_fd_sc_hd__clkbuf_1
XFILLER_0_6_249 vssd1 vssd1 vccd1 vccd1 sky130_fd_sc_hd__decap_3
XFILLER_0_27_355 vssd1 vssd1 vccd1 vccd1 sky130_fd_sc_hd__fill_1
X_2702_ _0731_ _0954_ u_core.u_regfile.rf\[28\]\[19\] vssd1 vssd1 vccd1 vccd1 _1160_
+ sky130_fd_sc_hd__o21a_1
XFILLER_0_54_141 vssd1 vssd1 vccd1 vccd1 sky130_fd_sc_hd__decap_3
X_3682_ _1833_ vssd1 vssd1 vccd1 vccd1 _0307_ sky130_fd_sc_hd__clkbuf_1
X_2633_ _0744_ _0748_ _0885_ u_core.u_regfile.rf\[4\]\[4\] _1090_ vssd1 vssd1 vccd1
+ vccd1 _1091_ sky130_fd_sc_hd__o221ai_4
XFILLER_0_10_200 vssd1 vssd1 vccd1 vccd1 sky130_fd_sc_hd__fill_2
XFILLER_0_2_433 vccd1 vssd1 vccd1 vssd1 sky130_ef_sc_hd__decap_12
X_2564_ _1020_ _1021_ vssd1 vssd1 vccd1 vccd1 _1022_ sky130_fd_sc_hd__nor2_1
XFILLER_0_2_477 vccd1 vssd1 vccd1 vssd1 sky130_ef_sc_hd__decap_12
X_4303_ clknet_leaf_48_clk _0114_ vssd1 vssd1 vccd1 vccd1 u_core.u_regfile.rf\[4\]\[3\]
+ sky130_fd_sc_hd__dfxtp_1
X_2495_ u_core.u_regfile.rf\[29\]\[8\] u_core.u_regfile.rf\[31\]\[8\] _0704_ vssd1
+ vssd1 vccd1 vccd1 _0953_ sky130_fd_sc_hd__mux2_1
XFILLER_0_10_288 vccd1 vssd1 vccd1 vssd1 sky130_ef_sc_hd__decap_12
X_4234_ clknet_leaf_3_clk _0049_ vssd1 vssd1 vccd1 vccd1 u_core.u_regfile.rf\[31\]\[2\]
+ sky130_fd_sc_hd__dfxtp_1
X_4165_ _2082_ vssd1 vssd1 vccd1 vccd1 _0541_ sky130_fd_sc_hd__clkbuf_1
X_3116_ u_timer.count_reg\[24\] _1544_ _1490_ vssd1 vssd1 vccd1 vccd1 _1545_ sky130_fd_sc_hd__o21ai_1
X_4096_ net309 vssd1 vssd1 vccd1 vccd1 _2044_ sky130_fd_sc_hd__clkbuf_1
X_3047_ _1494_ _1495_ _1496_ vssd1 vssd1 vccd1 vccd1 _1497_ sky130_fd_sc_hd__and3b_1
XFILLER_0_77_266 vccd1 vssd1 vccd1 vssd1 sky130_ef_sc_hd__decap_12
XFILLER_0_58_480 vccd1 vssd1 vccd1 vssd1 sky130_ef_sc_hd__decap_12
X_3949_ _1970_ vssd1 vssd1 vccd1 vccd1 _0437_ sky130_fd_sc_hd__clkbuf_1
XFILLER_0_45_141 vssd1 vssd1 vccd1 vccd1 sky130_fd_sc_hd__decap_6
XFILLER_0_73_494 vssd1 vssd1 vccd1 vccd1 sky130_fd_sc_hd__decap_8
XFILLER_0_21_509 vssd1 vssd1 vccd1 vccd1 sky130_fd_sc_hd__fill_1
XFILLER_0_64_450 vccd1 vssd1 vccd1 vssd1 sky130_ef_sc_hd__decap_12
XFILLER_0_51_155 vssd1 vssd1 vccd1 vccd1 sky130_fd_sc_hd__fill_2
XFILLER_0_10_79 vssd1 vssd1 vccd1 vccd1 sky130_fd_sc_hd__fill_1
X_2280_ _0731_ vssd1 vssd1 vccd1 vccd1 _0738_ sky130_fd_sc_hd__buf_4
XFILLER_0_79_509 vssd1 vssd1 vccd1 vccd1 sky130_fd_sc_hd__fill_1
XFILLER_0_35_54 vssd1 vssd1 vccd1 vccd1 sky130_fd_sc_hd__fill_2
XFILLER_0_59_222 vssd1 vssd1 vccd1 vccd1 sky130_fd_sc_hd__fill_2
XFILLER_0_74_225 vccd1 vssd1 vccd1 vssd1 sky130_ef_sc_hd__decap_12
X_3803_ _1409_ _1875_ _1404_ _1897_ vssd1 vssd1 vccd1 vccd1 _0364_ sky130_fd_sc_hd__a31o_1
X_4783_ clknet_leaf_26_clk _0551_ vssd1 vssd1 vccd1 vccd1 u_core.u_regfile.rf\[3\]\[16\]
+ sky130_fd_sc_hd__dfxtp_1
X_3734_ _1859_ vssd1 vssd1 vccd1 vccd1 _0333_ sky130_fd_sc_hd__clkbuf_1
XFILLER_0_42_133 vssd1 vssd1 vccd1 vccd1 sky130_fd_sc_hd__fill_2
X_3665_ net245 vssd1 vssd1 vccd1 vccd1 _1825_ sky130_fd_sc_hd__clkbuf_1
X_2616_ u_core.u_regfile.rf\[31\]\[5\] _0895_ _0745_ _0803_ vssd1 vssd1 vccd1 vccd1
+ _1074_ sky130_fd_sc_hd__o22a_1
XFILLER_0_23_391 vssd1 vssd1 vccd1 vccd1 sky130_fd_sc_hd__fill_1
X_3596_ _0778_ vssd1 vssd1 vccd1 vccd1 _1796_ sky130_fd_sc_hd__clkbuf_4
X_2547_ _0776_ _0697_ _0906_ _0916_ vssd1 vssd1 vccd1 vccd1 _1005_ sky130_fd_sc_hd__or4_2
X_2478_ _0873_ _0894_ _0919_ _0935_ vssd1 vssd1 vccd1 vccd1 _0936_ sky130_fd_sc_hd__nand4b_2
XFILLER_0_55_3 vccd1 vssd1 vccd1 vssd1 sky130_ef_sc_hd__decap_12
XFILLER_0_76_83 vssd1 vssd1 vccd1 vccd1 sky130_fd_sc_hd__fill_1
X_4217_ _1569_ _1481_ _2108_ vssd1 vssd1 vccd1 vccd1 _0567_ sky130_fd_sc_hd__a21oi_1
X_4148_ _2073_ _1686_ _1737_ vssd1 vssd1 vccd1 vccd1 _2074_ sky130_fd_sc_hd__nand3b_1
X_4079_ _2035_ vssd1 vssd1 vccd1 vccd1 _0502_ sky130_fd_sc_hd__clkbuf_1
XFILLER_0_65_225 vssd1 vssd1 vccd1 vccd1 sky130_fd_sc_hd__decap_3
XFILLER_0_18_141 vssd1 vssd1 vccd1 vccd1 sky130_fd_sc_hd__fill_1
XFILLER_0_80_228 vccd1 vssd1 vccd1 vssd1 sky130_ef_sc_hd__decap_12
XFILLER_0_84_501 vssd1 vssd1 vccd1 vccd1 sky130_fd_sc_hd__decap_8
XFILLER_0_52_442 vssd1 vssd1 vccd1 vccd1 sky130_fd_sc_hd__fill_1
X_3450_ _0889_ _0890_ _0875_ vssd1 vssd1 vccd1 vccd1 _1722_ sky130_fd_sc_hd__a21o_1
XFILLER_0_20_361 vssd1 vssd1 vccd1 vccd1 sky130_fd_sc_hd__decap_3
X_2401_ u_core.u_regfile.rf\[31\]\[14\] _0726_ _0858_ _0808_ vssd1 vssd1 vccd1 vccd1
+ _0859_ sky130_fd_sc_hd__a2bb2o_1
X_3381_ _1671_ _1672_ _1673_ net134 vssd1 vssd1 vccd1 vccd1 _0166_ sky130_fd_sc_hd__o31a_1
X_2332_ _0789_ _0712_ _0716_ vssd1 vssd1 vccd1 vccd1 _0790_ sky130_fd_sc_hd__and3_1
X_4002_ net169 vssd1 vssd1 vccd1 vccd1 _1997_ sky130_fd_sc_hd__clkbuf_1
X_2263_ u_imem.addr\[5\] vssd1 vssd1 vccd1 vccd1 _0721_ sky130_fd_sc_hd__buf_4
X_2194_ u_timer.count_reg\[7\] _0634_ _0652_ vssd1 vssd1 vccd1 vccd1 _0653_ sky130_fd_sc_hd__a21oi_1
XFILLER_0_1_55 vssd1 vssd1 vccd1 vccd1 sky130_fd_sc_hd__fill_1
XFILLER_0_62_41 vssd1 vssd1 vccd1 vccd1 sky130_fd_sc_hd__fill_2
XFILLER_0_47_258 vssd1 vssd1 vccd1 vccd1 sky130_fd_sc_hd__decap_8
X_4766_ clknet_leaf_12_clk _0001_ net24 vssd1 vssd1 vccd1 vccd1 u_pc.irq sky130_fd_sc_hd__dfrtp_1
XFILLER_0_15_100 vssd1 vssd1 vccd1 vccd1 sky130_fd_sc_hd__fill_2
X_3717_ net196 vssd1 vssd1 vccd1 vccd1 _1851_ sky130_fd_sc_hd__clkbuf_1
XFILLER_0_43_486 vssd1 vssd1 vccd1 vccd1 sky130_fd_sc_hd__fill_2
X_4697_ clknet_leaf_24_clk _0498_ vssd1 vssd1 vccd1 vccd1 u_core.u_regfile.rf\[25\]\[3\]
+ sky130_fd_sc_hd__dfxtp_1
X_3648_ _1816_ vssd1 vssd1 vccd1 vccd1 _0290_ sky130_fd_sc_hd__clkbuf_1
X_3579_ _1487_ vssd1 vssd1 vccd1 vccd1 _1791_ sky130_fd_sc_hd__buf_2
Xhold13 u_core.u_regfile.rf\[7\]\[19\] vssd1 vssd1 vccd1 vccd1 net46 sky130_fd_sc_hd__dlygate4sd3_1
Xhold35 u_core.u_regfile.rf\[6\]\[2\] vssd1 vssd1 vccd1 vccd1 net68 sky130_fd_sc_hd__dlygate4sd3_1
Xhold46 u_core.u_regfile.rf\[5\]\[31\] vssd1 vssd1 vccd1 vccd1 net79 sky130_fd_sc_hd__dlygate4sd3_1
Xhold24 u_core.u_regfile.rf\[5\]\[28\] vssd1 vssd1 vccd1 vccd1 net57 sky130_fd_sc_hd__dlygate4sd3_1
Xhold57 u_core.u_regfile.rf\[7\]\[2\] vssd1 vssd1 vccd1 vccd1 net90 sky130_fd_sc_hd__dlygate4sd3_1
Xhold68 u_core.u_regfile.rf\[6\]\[29\] vssd1 vssd1 vccd1 vccd1 net101 sky130_fd_sc_hd__dlygate4sd3_1
Xhold79 u_core.u_regfile.rf\[5\]\[17\] vssd1 vssd1 vccd1 vccd1 net112 sky130_fd_sc_hd__dlygate4sd3_1
XFILLER_0_85_309 vccd1 vssd1 vccd1 vssd1 sky130_ef_sc_hd__decap_12
XFILLER_0_19_472 vssd1 vssd1 vccd1 vccd1 sky130_fd_sc_hd__decap_4
XFILLER_0_34_475 vssd1 vssd1 vccd1 vccd1 sky130_fd_sc_hd__fill_1
XFILLER_0_1_509 vssd1 vssd1 vccd1 vccd1 sky130_fd_sc_hd__fill_1
XTAP_309 vssd1 vccd1 sky130_fd_sc_hd__tapvpwrvgnd_1
XFILLER_0_76_309 vccd1 vssd1 vccd1 vssd1 sky130_ef_sc_hd__decap_12
XFILLER_0_8_108 vssd1 vssd1 vccd1 vccd1 sky130_fd_sc_hd__fill_1
XFILLER_0_29_225 vssd1 vssd1 vccd1 vccd1 sky130_fd_sc_hd__decap_4
XFILLER_0_32_11 vssd1 vssd1 vccd1 vccd1 sky130_fd_sc_hd__fill_1
X_2950_ _0782_ _0775_ _1406_ vssd1 vssd1 vccd1 vccd1 _1408_ sky130_fd_sc_hd__nor3_1
XFILLER_0_84_342 vccd1 vssd1 vccd1 vssd1 sky130_ef_sc_hd__decap_12
X_2881_ _1275_ _1276_ _1280_ vssd1 vssd1 vccd1 vccd1 _1339_ sky130_fd_sc_hd__o21ai_2
X_4620_ clknet_leaf_46_clk _0421_ vssd1 vssd1 vccd1 vccd1 u_core.u_regfile.rf\[1\]\[22\]
+ sky130_fd_sc_hd__dfxtp_1
XFILLER_0_37_291 vssd1 vssd1 vccd1 vccd1 sky130_fd_sc_hd__decap_4
X_4551_ clknet_leaf_29_clk _0352_ vssd1 vssd1 vccd1 vccd1 u_core.u_regfile.rf\[28\]\[17\]
+ sky130_fd_sc_hd__dfxtp_1
X_4482_ clknet_leaf_23_clk _0283_ vssd1 vssd1 vccd1 vccd1 u_core.u_regfile.rf\[30\]\[12\]
+ sky130_fd_sc_hd__dfxtp_1
Xhold505 u_core.u_regfile.rf\[4\]\[12\] vssd1 vssd1 vccd1 vccd1 net538 sky130_fd_sc_hd__dlygate4sd3_1
XFILLER_0_40_434 vssd1 vssd1 vccd1 vccd1 sky130_fd_sc_hd__fill_1
Xhold527 net3 vssd1 vssd1 vccd1 vccd1 net560 sky130_fd_sc_hd__dlygate4sd3_1
Xhold516 u_timer.threshold_reg\[11\] vssd1 vssd1 vccd1 vccd1 net549 sky130_fd_sc_hd__dlygate4sd3_1
X_3502_ _1683_ _1413_ _1713_ _1480_ _0575_ vssd1 vssd1 vccd1 vccd1 _1756_ sky130_fd_sc_hd__a41o_1
X_3433_ _1423_ _1424_ _1428_ _1430_ vssd1 vssd1 vccd1 vccd1 _1709_ sky130_fd_sc_hd__and4_1
XTAP_810 vssd1 vccd1 sky130_fd_sc_hd__tapvpwrvgnd_1
XTAP_843 vssd1 vccd1 sky130_fd_sc_hd__tapvpwrvgnd_1
XTAP_832 vssd1 vccd1 sky130_fd_sc_hd__tapvpwrvgnd_1
XTAP_821 vssd1 vccd1 sky130_fd_sc_hd__tapvpwrvgnd_1
X_3364_ _0898_ vssd1 vssd1 vccd1 vccd1 _1670_ sky130_fd_sc_hd__buf_2
XTAP_876 vssd1 vccd1 sky130_fd_sc_hd__tapvpwrvgnd_1
XTAP_865 vssd1 vccd1 sky130_fd_sc_hd__tapvpwrvgnd_1
XTAP_854 vssd1 vccd1 sky130_fd_sc_hd__tapvpwrvgnd_1
X_3295_ _1638_ vssd1 vssd1 vccd1 vccd1 _0115_ sky130_fd_sc_hd__clkbuf_1
X_2315_ _0722_ vssd1 vssd1 vccd1 vccd1 _0773_ sky130_fd_sc_hd__buf_4
XTAP_898 vssd1 vccd1 sky130_fd_sc_hd__tapvpwrvgnd_1
XTAP_887 vssd1 vccd1 sky130_fd_sc_hd__tapvpwrvgnd_1
X_2246_ _0687_ vssd1 vssd1 vccd1 vccd1 _0704_ sky130_fd_sc_hd__buf_4
XFILLER_0_79_158 vssd1 vssd1 vccd1 vccd1 sky130_fd_sc_hd__decap_8
X_2177_ _0635_ u_timer.count_reg\[6\] vssd1 vssd1 vccd1 vccd1 _0636_ sky130_fd_sc_hd__nand2_1
XFILLER_0_73_51 vssd1 vssd1 vccd1 vccd1 sky130_fd_sc_hd__decap_4
XFILLER_0_18_3 vccd1 vssd1 vccd1 vssd1 sky130_ef_sc_hd__decap_12
XFILLER_0_79_169 vssd1 vssd1 vccd1 vccd1 sky130_fd_sc_hd__decap_6
XFILLER_0_75_353 vssd1 vssd1 vccd1 vccd1 sky130_fd_sc_hd__fill_1
XFILLER_0_35_206 vssd1 vssd1 vccd1 vccd1 sky130_fd_sc_hd__fill_1
X_4749_ clknet_leaf_21_clk _0013_ net31 vssd1 vssd1 vccd1 vccd1 u_timer.count_reg\[15\]
+ sky130_fd_sc_hd__dfrtp_4
XFILLER_0_31_434 vssd1 vssd1 vccd1 vccd1 sky130_fd_sc_hd__fill_2
XFILLER_0_3_391 vssd1 vssd1 vccd1 vccd1 sky130_fd_sc_hd__fill_1
XFILLER_0_31_489 vssd1 vssd1 vccd1 vccd1 sky130_fd_sc_hd__fill_1
XFILLER_0_58_309 vssd1 vssd1 vccd1 vccd1 sky130_fd_sc_hd__fill_1
XPHY_142 vssd1 vssd1 vccd1 vccd1 sky130_fd_sc_hd__decap_3
XPHY_120 vssd1 vssd1 vccd1 vccd1 sky130_fd_sc_hd__decap_3
XPHY_131 vssd1 vssd1 vccd1 vccd1 sky130_fd_sc_hd__decap_3
XPHY_164 vssd1 vssd1 vccd1 vccd1 sky130_fd_sc_hd__decap_3
XPHY_153 vssd1 vssd1 vccd1 vccd1 sky130_fd_sc_hd__decap_3
XFILLER_0_66_397 vssd1 vssd1 vccd1 vccd1 sky130_fd_sc_hd__fill_2
XFILLER_0_78_29 vccd1 vssd1 vccd1 vssd1 sky130_ef_sc_hd__decap_12
XFILLER_0_1_317 vccd1 vssd1 vccd1 vssd1 sky130_ef_sc_hd__decap_12
XFILLER_0_27_11 vssd1 vssd1 vccd1 vccd1 sky130_fd_sc_hd__fill_2
X_3080_ _1519_ _1495_ _1520_ vssd1 vssd1 vccd1 vccd1 _1521_ sky130_fd_sc_hd__and3b_1
XFILLER_0_27_44 vssd1 vssd1 vccd1 vccd1 sky130_fd_sc_hd__fill_2
XFILLER_0_76_139 vssd1 vssd1 vccd1 vccd1 sky130_fd_sc_hd__fill_1
XPHY_0 vssd1 vssd1 vccd1 vccd1 sky130_fd_sc_hd__decap_3
X_3982_ net328 vssd1 vssd1 vccd1 vccd1 _1987_ sky130_fd_sc_hd__clkbuf_1
XFILLER_0_43_65 vssd1 vssd1 vccd1 vccd1 sky130_fd_sc_hd__decap_8
X_2933_ _1178_ _1008_ _1152_ vssd1 vssd1 vccd1 vccd1 _1391_ sky130_fd_sc_hd__or3_1
X_2864_ _1304_ _0762_ u_core.u_regfile.rf\[6\]\[31\] vssd1 vssd1 vccd1 vccd1 _1322_
+ sky130_fd_sc_hd__o21a_1
X_4603_ clknet_leaf_45_clk _0404_ vssd1 vssd1 vccd1 vccd1 u_core.u_regfile.rf\[1\]\[5\]
+ sky130_fd_sc_hd__dfxtp_1
X_2795_ _1251_ _1252_ vssd1 vssd1 vccd1 vccd1 _1253_ sky130_fd_sc_hd__nand2_1
X_4534_ clknet_leaf_5_clk _0335_ vssd1 vssd1 vccd1 vccd1 u_core.u_regfile.rf\[28\]\[0\]
+ sky130_fd_sc_hd__dfxtp_1
Xhold302 u_core.u_regfile.rf\[2\]\[23\] vssd1 vssd1 vccd1 vccd1 net335 sky130_fd_sc_hd__dlygate4sd3_1
XFILLER_0_13_456 vssd1 vssd1 vccd1 vccd1 sky130_fd_sc_hd__decap_3
Xhold335 u_core.u_regfile.rf\[29\]\[15\] vssd1 vssd1 vccd1 vccd1 net368 sky130_fd_sc_hd__dlygate4sd3_1
XFILLER_0_40_253 vssd1 vssd1 vccd1 vccd1 sky130_fd_sc_hd__decap_8
Xhold313 u_core.u_regfile.rf\[30\]\[18\] vssd1 vssd1 vccd1 vccd1 net346 sky130_fd_sc_hd__dlygate4sd3_1
Xhold324 u_core.u_regfile.rf\[26\]\[28\] vssd1 vssd1 vccd1 vccd1 net357 sky130_fd_sc_hd__dlygate4sd3_1
Xhold368 u_core.u_regfile.rf\[1\]\[1\] vssd1 vssd1 vccd1 vccd1 net401 sky130_fd_sc_hd__dlygate4sd3_1
Xhold346 u_core.u_regfile.rf\[25\]\[23\] vssd1 vssd1 vccd1 vccd1 net379 sky130_fd_sc_hd__dlygate4sd3_1
X_4465_ clknet_leaf_2_clk _0266_ vssd1 vssd1 vccd1 vccd1 u_core.u_regfile.rf\[7\]\[27\]
+ sky130_fd_sc_hd__dfxtp_1
XFILLER_0_40_286 vssd1 vssd1 vccd1 vccd1 sky130_fd_sc_hd__fill_1
Xhold357 u_core.u_regfile.rf\[29\]\[21\] vssd1 vssd1 vccd1 vccd1 net390 sky130_fd_sc_hd__dlygate4sd3_1
XFILLER_0_0_361 vssd1 vssd1 vccd1 vccd1 sky130_fd_sc_hd__decap_3
XFILLER_0_0_372 vssd1 vssd1 vccd1 vccd1 sky130_fd_sc_hd__fill_2
Xhold379 u_core.u_regfile.rf\[29\]\[8\] vssd1 vssd1 vccd1 vccd1 net412 sky130_fd_sc_hd__dlygate4sd3_1
X_4396_ clknet_leaf_3_clk _0207_ vssd1 vssd1 vccd1 vccd1 u_core.u_regfile.rf\[29\]\[0\]
+ sky130_fd_sc_hd__dfxtp_1
X_3416_ _1093_ _1693_ _1678_ _1694_ _1695_ vssd1 vssd1 vccd1 vccd1 _1696_ sky130_fd_sc_hd__o2111a_1
X_3347_ _1664_ vssd1 vssd1 vccd1 vccd1 _0141_ sky130_fd_sc_hd__clkbuf_1
XTAP_640 vssd1 vccd1 sky130_fd_sc_hd__tapvpwrvgnd_1
XTAP_651 vssd1 vccd1 sky130_fd_sc_hd__tapvpwrvgnd_1
XTAP_662 vssd1 vccd1 sky130_fd_sc_hd__tapvpwrvgnd_1
XTAP_673 vssd1 vccd1 sky130_fd_sc_hd__tapvpwrvgnd_1
XTAP_684 vssd1 vccd1 sky130_fd_sc_hd__tapvpwrvgnd_1
XTAP_695 vssd1 vccd1 sky130_fd_sc_hd__tapvpwrvgnd_1
XFILLER_0_84_83 vssd1 vssd1 vccd1 vccd1 sky130_fd_sc_hd__fill_1
X_3278_ _1629_ _1630_ _1631_ net107 vssd1 vssd1 vccd1 vccd1 _0105_ sky130_fd_sc_hd__o31a_1
X_2229_ u_imem.addr\[5\] vssd1 vssd1 vccd1 vccd1 _0687_ sky130_fd_sc_hd__buf_4
XFILLER_0_67_117 vssd1 vssd1 vccd1 vccd1 sky130_fd_sc_hd__fill_1
XFILLER_0_63_345 vssd1 vssd1 vccd1 vccd1 sky130_fd_sc_hd__fill_2
XFILLER_0_31_275 vssd1 vssd1 vccd1 vccd1 sky130_fd_sc_hd__decap_4
XFILLER_0_7_3 vccd1 vssd1 vccd1 vssd1 sky130_ef_sc_hd__decap_12
XFILLER_0_54_312 vssd1 vssd1 vccd1 vccd1 sky130_fd_sc_hd__fill_2
X_2580_ _0860_ _0713_ _1037_ vssd1 vssd1 vccd1 vccd1 _1038_ sky130_fd_sc_hd__nand3_1
XFILLER_0_1_125 vccd1 vssd1 vccd1 vssd1 sky130_ef_sc_hd__decap_12
XFILLER_0_22_264 vssd1 vssd1 vccd1 vccd1 sky130_fd_sc_hd__fill_1
XFILLER_0_10_437 vssd1 vssd1 vccd1 vccd1 sky130_fd_sc_hd__decap_3
X_4250_ clknet_leaf_41_clk _0065_ vssd1 vssd1 vccd1 vccd1 u_core.u_regfile.rf\[31\]\[18\]
+ sky130_fd_sc_hd__dfxtp_1
X_3201_ net516 vssd1 vssd1 vccd1 vccd1 _1602_ sky130_fd_sc_hd__clkbuf_1
XFILLER_0_38_43 vccd1 vssd1 vccd1 vssd1 sky130_ef_sc_hd__decap_12
X_4181_ _2090_ vssd1 vssd1 vccd1 vccd1 _0549_ sky130_fd_sc_hd__clkbuf_1
X_3132_ _1555_ _1490_ _1556_ vssd1 vssd1 vccd1 vccd1 _1557_ sky130_fd_sc_hd__and3_1
X_3063_ u_timer.count_reg\[7\] _1502_ u_timer.count_reg\[8\] vssd1 vssd1 vccd1 vccd1
+ _1508_ sky130_fd_sc_hd__a21oi_1
XFILLER_0_77_415 vccd1 vssd1 vccd1 vssd1 sky130_ef_sc_hd__decap_12
X_3965_ _1978_ vssd1 vssd1 vccd1 vccd1 _0445_ sky130_fd_sc_hd__clkbuf_1
X_3896_ net369 vssd1 vssd1 vccd1 vccd1 _1944_ sky130_fd_sc_hd__clkbuf_1
X_2916_ _1334_ _1371_ _1372_ _1373_ vssd1 vssd1 vccd1 vccd1 _1374_ sky130_fd_sc_hd__o211ai_1
XFILLER_0_70_85 vccd1 vssd1 vccd1 vssd1 sky130_ef_sc_hd__decap_12
X_2847_ _1304_ _0762_ u_core.u_regfile.rf\[6\]\[30\] vssd1 vssd1 vccd1 vccd1 _1305_
+ sky130_fd_sc_hd__o21a_1
XFILLER_0_85_3 vccd1 vssd1 vccd1 vssd1 sky130_ef_sc_hd__decap_12
XFILLER_0_13_220 vssd1 vssd1 vccd1 vccd1 sky130_fd_sc_hd__decap_4
Xhold110 u_core.u_regfile.rf\[6\]\[31\] vssd1 vssd1 vccd1 vccd1 net143 sky130_fd_sc_hd__dlygate4sd3_1
X_2778_ _0965_ _1225_ _1231_ _1235_ vssd1 vssd1 vccd1 vccd1 _1236_ sky130_fd_sc_hd__a31o_1
Xhold121 u_core.u_regfile.rf\[25\]\[11\] vssd1 vssd1 vccd1 vccd1 net154 sky130_fd_sc_hd__dlygate4sd3_1
Xhold132 u_core.u_regfile.rf\[25\]\[0\] vssd1 vssd1 vccd1 vccd1 net165 sky130_fd_sc_hd__dlygate4sd3_1
Xhold143 u_core.u_regfile.rf\[27\]\[9\] vssd1 vssd1 vccd1 vccd1 net176 sky130_fd_sc_hd__dlygate4sd3_1
X_4517_ clknet_leaf_32_clk _0318_ vssd1 vssd1 vccd1 vccd1 u_core.u_regfile.rf\[2\]\[15\]
+ sky130_fd_sc_hd__dfxtp_1
Xhold165 u_core.u_regfile.rf\[26\]\[6\] vssd1 vssd1 vccd1 vccd1 net198 sky130_fd_sc_hd__dlygate4sd3_1
Xhold176 u_core.u_regfile.rf\[24\]\[7\] vssd1 vssd1 vccd1 vccd1 net209 sky130_fd_sc_hd__dlygate4sd3_1
Xhold154 u_core.u_regfile.rf\[24\]\[16\] vssd1 vssd1 vccd1 vccd1 net187 sky130_fd_sc_hd__dlygate4sd3_1
X_4448_ clknet_leaf_49_clk _0249_ vssd1 vssd1 vccd1 vccd1 u_core.u_regfile.rf\[7\]\[10\]
+ sky130_fd_sc_hd__dfxtp_1
Xhold187 u_core.u_regfile.rf\[3\]\[28\] vssd1 vssd1 vccd1 vccd1 net220 sky130_fd_sc_hd__dlygate4sd3_1
Xhold198 u_core.u_regfile.rf\[27\]\[5\] vssd1 vssd1 vccd1 vccd1 net231 sky130_fd_sc_hd__dlygate4sd3_1
X_4379_ clknet_leaf_20_clk _0190_ net30 vssd1 vssd1 vccd1 vccd1 u_timer.threshold_reg\[15\]
+ sky130_fd_sc_hd__dfrtp_1
XTAP_470 vssd1 vccd1 sky130_fd_sc_hd__tapvpwrvgnd_1
XTAP_481 vssd1 vccd1 sky130_fd_sc_hd__tapvpwrvgnd_1
XTAP_492 vssd1 vccd1 sky130_fd_sc_hd__tapvpwrvgnd_1
XFILLER_0_83_429 vccd1 vssd1 vccd1 vssd1 sky130_ef_sc_hd__decap_12
XFILLER_0_59_415 vssd1 vssd1 vccd1 vccd1 sky130_fd_sc_hd__fill_1
X_3750_ _1708_ net525 _1868_ vssd1 vssd1 vccd1 vccd1 _1869_ sky130_fd_sc_hd__mux2_1
XFILLER_0_40_33 vssd1 vssd1 vccd1 vccd1 sky130_fd_sc_hd__fill_2
X_2701_ u_core.u_regfile.rf\[29\]\[19\] u_core.u_regfile.rf\[31\]\[19\] _0840_ vssd1
+ vssd1 vccd1 vccd1 _1159_ sky130_fd_sc_hd__mux2_1
X_3681_ net207 vssd1 vssd1 vccd1 vccd1 _1833_ sky130_fd_sc_hd__clkbuf_1
XFILLER_0_27_389 vssd1 vssd1 vccd1 vccd1 sky130_fd_sc_hd__decap_3
XFILLER_0_40_77 vssd1 vssd1 vccd1 vccd1 sky130_fd_sc_hd__fill_1
XFILLER_0_54_197 vssd1 vssd1 vccd1 vccd1 sky130_fd_sc_hd__decap_4
X_2632_ _1088_ _1089_ _0750_ vssd1 vssd1 vccd1 vccd1 _1090_ sky130_fd_sc_hd__nand3_1
XFILLER_0_2_401 vccd1 vssd1 vccd1 vssd1 sky130_ef_sc_hd__decap_12
XFILLER_0_2_445 vccd1 vssd1 vccd1 vssd1 sky130_ef_sc_hd__decap_12
X_2563_ _0779_ _1009_ _1014_ _1019_ vssd1 vssd1 vccd1 vccd1 _1021_ sky130_fd_sc_hd__nor4_1
X_4302_ clknet_leaf_47_clk _0113_ vssd1 vssd1 vccd1 vccd1 u_core.u_regfile.rf\[4\]\[2\]
+ sky130_fd_sc_hd__dfxtp_1
XFILLER_0_2_489 vccd1 vssd1 vccd1 vssd1 sky130_ef_sc_hd__decap_12
X_2494_ _0769_ vssd1 vssd1 vccd1 vccd1 _0952_ sky130_fd_sc_hd__buf_4
X_4233_ clknet_leaf_8_clk _0048_ vssd1 vssd1 vccd1 vccd1 u_core.u_regfile.rf\[31\]\[1\]
+ sky130_fd_sc_hd__dfxtp_1
X_4164_ net223 vssd1 vssd1 vccd1 vccd1 _2082_ sky130_fd_sc_hd__clkbuf_1
XFILLER_0_4_44 vssd1 vssd1 vccd1 vccd1 sky130_fd_sc_hd__fill_1
XFILLER_0_65_41 vccd1 vssd1 vccd1 vssd1 sky130_ef_sc_hd__decap_12
X_3115_ u_timer.count_reg\[23\] u_timer.count_reg\[22\] _1541_ vssd1 vssd1 vccd1 vccd1
+ _1544_ sky130_fd_sc_hd__and3_2
X_4095_ _2043_ vssd1 vssd1 vccd1 vccd1 _0510_ sky130_fd_sc_hd__clkbuf_1
X_3046_ u_timer.count_reg\[2\] u_timer.count_reg\[1\] u_timer.count_reg\[0\] u_timer.count_reg\[3\]
+ vssd1 vssd1 vccd1 vccd1 _1496_ sky130_fd_sc_hd__a31o_1
XFILLER_0_77_212 vssd1 vssd1 vccd1 vccd1 sky130_fd_sc_hd__fill_2
XFILLER_0_81_51 vssd1 vssd1 vccd1 vccd1 sky130_fd_sc_hd__decap_4
XFILLER_0_77_278 vssd1 vssd1 vccd1 vccd1 sky130_fd_sc_hd__fill_2
XFILLER_0_45_120 vssd1 vssd1 vccd1 vccd1 sky130_fd_sc_hd__fill_1
XFILLER_0_58_492 vccd1 vssd1 vccd1 vssd1 sky130_ef_sc_hd__decap_12
X_3948_ net198 vssd1 vssd1 vccd1 vccd1 _1970_ sky130_fd_sc_hd__clkbuf_1
XFILLER_0_18_356 vssd1 vssd1 vccd1 vccd1 sky130_fd_sc_hd__decap_3
X_3879_ _1935_ vssd1 vssd1 vccd1 vccd1 _0402_ sky130_fd_sc_hd__clkbuf_1
XFILLER_0_68_245 vssd1 vssd1 vccd1 vccd1 sky130_fd_sc_hd__decap_6
XFILLER_0_56_429 vssd1 vssd1 vccd1 vccd1 sky130_fd_sc_hd__fill_1
XFILLER_0_64_462 vccd1 vssd1 vccd1 vssd1 sky130_ef_sc_hd__decap_12
XFILLER_0_36_164 vssd1 vssd1 vccd1 vccd1 sky130_fd_sc_hd__decap_8
XFILLER_0_36_197 vssd1 vssd1 vccd1 vccd1 sky130_fd_sc_hd__decap_6
XFILLER_0_10_47 vssd1 vssd1 vccd1 vccd1 sky130_fd_sc_hd__fill_1
XFILLER_0_51_167 vssd1 vssd1 vccd1 vccd1 sky130_fd_sc_hd__fill_1
XFILLER_0_51_189 vssd1 vssd1 vccd1 vccd1 sky130_fd_sc_hd__decap_4
XFILLER_0_35_11 vssd1 vssd1 vccd1 vccd1 sky130_fd_sc_hd__decap_3
XFILLER_0_59_278 vssd1 vssd1 vccd1 vccd1 sky130_fd_sc_hd__fill_2
XFILLER_0_74_237 vssd1 vssd1 vccd1 vccd1 sky130_fd_sc_hd__decap_4
X_3802_ _1484_ _0737_ net461 vssd1 vssd1 vccd1 vccd1 _1897_ sky130_fd_sc_hd__o21a_1
XFILLER_0_27_131 vssd1 vssd1 vccd1 vccd1 sky130_fd_sc_hd__decap_4
X_4782_ clknet_leaf_24_clk _0550_ vssd1 vssd1 vccd1 vccd1 u_core.u_regfile.rf\[3\]\[15\]
+ sky130_fd_sc_hd__dfxtp_1
XFILLER_0_82_281 vssd1 vssd1 vccd1 vccd1 sky130_fd_sc_hd__fill_1
X_3733_ net297 vssd1 vssd1 vccd1 vccd1 _1859_ sky130_fd_sc_hd__clkbuf_1
XFILLER_0_15_337 vssd1 vssd1 vccd1 vccd1 sky130_fd_sc_hd__decap_4
X_3664_ _1824_ vssd1 vssd1 vccd1 vccd1 _0298_ sky130_fd_sc_hd__clkbuf_1
X_2615_ _1022_ _1070_ _1072_ vssd1 vssd1 vccd1 vccd1 _1073_ sky130_fd_sc_hd__o21bai_4
XFILLER_0_2_253 vccd1 vssd1 vccd1 vssd1 sky130_ef_sc_hd__decap_12
X_3595_ _1794_ _1795_ _1793_ net46 vssd1 vssd1 vccd1 vccd1 _0258_ sky130_fd_sc_hd__o31a_1
X_2546_ _0776_ _0698_ _0916_ _0906_ vssd1 vssd1 vccd1 vccd1 _1004_ sky130_fd_sc_hd__o31a_1
X_2477_ _0920_ _0927_ _0932_ _0934_ vssd1 vssd1 vccd1 vccd1 _0935_ sky130_fd_sc_hd__o31ai_2
XFILLER_0_48_3 vccd1 vssd1 vccd1 vssd1 sky130_ef_sc_hd__decap_12
X_4216_ _1681_ _1682_ net12 _1694_ _1695_ vssd1 vssd1 vccd1 vccd1 _2108_ sky130_fd_sc_hd__o2111a_1
X_4147_ _1700_ _1112_ vssd1 vssd1 vccd1 vccd1 _2073_ sky130_fd_sc_hd__or2_1
X_4078_ net327 vssd1 vssd1 vccd1 vccd1 _2035_ sky130_fd_sc_hd__clkbuf_1
X_3029_ _0712_ vssd1 vssd1 vccd1 vccd1 _1484_ sky130_fd_sc_hd__buf_4
XFILLER_0_65_248 vccd1 vssd1 vccd1 vssd1 sky130_ef_sc_hd__decap_12
XFILLER_0_37_495 vssd1 vssd1 vccd1 vccd1 sky130_fd_sc_hd__fill_1
XFILLER_0_21_57 vssd1 vssd1 vccd1 vccd1 sky130_fd_sc_hd__fill_1
X_2400_ _0857_ vssd1 vssd1 vccd1 vccd1 _0858_ sky130_fd_sc_hd__clkbuf_4
X_3380_ _1671_ _1672_ _1673_ net51 vssd1 vssd1 vccd1 vccd1 _0165_ sky130_fd_sc_hd__o31a_1
X_2331_ u_core.u_regfile.rf\[29\]\[28\] u_core.u_regfile.rf\[31\]\[28\] _0706_ vssd1
+ vssd1 vccd1 vccd1 _0789_ sky130_fd_sc_hd__mux2_1
X_2262_ u_imem.addr\[4\] vssd1 vssd1 vccd1 vccd1 _0720_ sky130_fd_sc_hd__buf_4
X_4001_ _1996_ vssd1 vssd1 vccd1 vccd1 _0463_ sky130_fd_sc_hd__clkbuf_1
XFILLER_0_46_43 vssd1 vssd1 vccd1 vccd1 sky130_fd_sc_hd__fill_2
X_2193_ _0636_ _0651_ u_timer.count_reg\[7\] _0634_ vssd1 vssd1 vccd1 vccd1 _0652_
+ sky130_fd_sc_hd__o2bb2a_1
XFILLER_0_46_98 vssd1 vssd1 vccd1 vccd1 sky130_fd_sc_hd__fill_2
X_4765_ clknet_leaf_13_clk _0031_ net25 vssd1 vssd1 vccd1 vccd1 u_timer.count_reg\[31\]
+ sky130_fd_sc_hd__dfrtp_1
X_3716_ _1850_ vssd1 vssd1 vccd1 vccd1 _0324_ sky130_fd_sc_hd__clkbuf_1
XFILLER_0_30_104 vssd1 vssd1 vccd1 vccd1 sky130_fd_sc_hd__fill_2
X_4696_ clknet_leaf_34_clk _0497_ vssd1 vssd1 vccd1 vccd1 u_core.u_regfile.rf\[25\]\[2\]
+ sky130_fd_sc_hd__dfxtp_1
X_3647_ net229 vssd1 vssd1 vccd1 vccd1 _1816_ sky130_fd_sc_hd__clkbuf_1
X_3578_ _1632_ _1633_ _1790_ net100 vssd1 vssd1 vccd1 vccd1 _0246_ sky130_fd_sc_hd__o31a_1
X_2529_ _0770_ _0985_ _0702_ _0909_ _0986_ vssd1 vssd1 vccd1 vccd1 _0987_ sky130_fd_sc_hd__a221o_2
Xhold14 u_core.u_regfile.rf\[6\]\[1\] vssd1 vssd1 vccd1 vccd1 net47 sky130_fd_sc_hd__dlygate4sd3_1
Xhold36 u_core.u_regfile.rf\[7\]\[23\] vssd1 vssd1 vccd1 vccd1 net69 sky130_fd_sc_hd__dlygate4sd3_1
Xhold47 u_core.u_regfile.rf\[5\]\[20\] vssd1 vssd1 vccd1 vccd1 net80 sky130_fd_sc_hd__dlygate4sd3_1
Xhold25 u_core.u_regfile.rf\[5\]\[30\] vssd1 vssd1 vccd1 vccd1 net58 sky130_fd_sc_hd__dlygate4sd3_1
Xhold69 u_core.u_regfile.rf\[28\]\[19\] vssd1 vssd1 vccd1 vccd1 net102 sky130_fd_sc_hd__dlygate4sd3_1
Xhold58 u_pc.irq vssd1 vssd1 vccd1 vccd1 net91 sky130_fd_sc_hd__clkbuf_2
XFILLER_0_78_340 vssd1 vssd1 vccd1 vccd1 sky130_fd_sc_hd__fill_2
XFILLER_0_81_505 vssd1 vssd1 vccd1 vccd1 sky130_fd_sc_hd__decap_4
XFILLER_0_19_495 vssd1 vssd1 vccd1 vccd1 sky130_fd_sc_hd__decap_8
XFILLER_0_34_421 vssd1 vssd1 vccd1 vccd1 sky130_fd_sc_hd__decap_4
XFILLER_0_34_465 vssd1 vssd1 vccd1 vccd1 sky130_fd_sc_hd__fill_2
XFILLER_0_61_251 vssd1 vssd1 vccd1 vccd1 sky130_fd_sc_hd__fill_1
XFILLER_0_16_79 vssd1 vssd1 vccd1 vccd1 sky130_fd_sc_hd__decap_4
XFILLER_0_84_365 vccd1 vssd1 vccd1 vssd1 sky130_ef_sc_hd__decap_12
XFILLER_0_84_354 vssd1 vssd1 vccd1 vccd1 sky130_fd_sc_hd__decap_8
X_2880_ _0850_ _0821_ _1336_ vssd1 vssd1 vccd1 vccd1 _1338_ sky130_fd_sc_hd__nor3b_2
X_4550_ clknet_leaf_30_clk _0351_ vssd1 vssd1 vccd1 vccd1 u_core.u_regfile.rf\[28\]\[16\]
+ sky130_fd_sc_hd__dfxtp_1
Xhold517 u_timer.threshold_reg\[30\] vssd1 vssd1 vccd1 vccd1 net550 sky130_fd_sc_hd__dlygate4sd3_1
Xhold506 u_core.u_regfile.rf\[1\]\[3\] vssd1 vssd1 vccd1 vccd1 net539 sky130_fd_sc_hd__dlygate4sd3_1
X_4481_ clknet_leaf_32_clk _0282_ vssd1 vssd1 vccd1 vccd1 u_core.u_regfile.rf\[30\]\[11\]
+ sky130_fd_sc_hd__dfxtp_1
X_3501_ _1406_ _1741_ _1755_ vssd1 vssd1 vccd1 vccd1 _0204_ sky130_fd_sc_hd__o21ai_1
X_3432_ _1437_ _1436_ vssd1 vssd1 vccd1 vccd1 _1708_ sky130_fd_sc_hd__nand2_1
Xhold528 u_core.u_regfile.rf\[31\]\[31\] vssd1 vssd1 vccd1 vccd1 net561 sky130_fd_sc_hd__dlygate4sd3_1
X_3363_ _1484_ vssd1 vssd1 vccd1 vccd1 _1669_ sky130_fd_sc_hd__clkbuf_4
XTAP_800 vssd1 vccd1 sky130_fd_sc_hd__tapvpwrvgnd_1
XTAP_844 vssd1 vccd1 sky130_fd_sc_hd__tapvpwrvgnd_1
XTAP_833 vssd1 vccd1 sky130_fd_sc_hd__tapvpwrvgnd_1
XTAP_822 vssd1 vccd1 sky130_fd_sc_hd__tapvpwrvgnd_1
XTAP_811 vssd1 vccd1 sky130_fd_sc_hd__tapvpwrvgnd_1
XTAP_877 vssd1 vccd1 sky130_fd_sc_hd__tapvpwrvgnd_1
XTAP_866 vssd1 vccd1 sky130_fd_sc_hd__tapvpwrvgnd_1
XTAP_855 vssd1 vccd1 sky130_fd_sc_hd__tapvpwrvgnd_1
X_3294_ net537 vssd1 vssd1 vccd1 vccd1 _1638_ sky130_fd_sc_hd__clkbuf_1
X_2314_ _0771_ vssd1 vssd1 vccd1 vccd1 _0772_ sky130_fd_sc_hd__clkbuf_4
XTAP_899 vssd1 vccd1 sky130_fd_sc_hd__tapvpwrvgnd_1
XTAP_888 vssd1 vccd1 sky130_fd_sc_hd__tapvpwrvgnd_1
X_2245_ _0702_ vssd1 vssd1 vccd1 vccd1 _0703_ sky130_fd_sc_hd__clkbuf_4
X_2176_ net345 vssd1 vssd1 vccd1 vccd1 _0635_ sky130_fd_sc_hd__inv_2
XFILLER_0_63_505 vssd1 vssd1 vccd1 vccd1 sky130_fd_sc_hd__decap_4
X_4748_ clknet_leaf_21_clk _0012_ net30 vssd1 vssd1 vccd1 vccd1 u_timer.count_reg\[14\]
+ sky130_fd_sc_hd__dfrtp_2
X_4679_ clknet_leaf_47_clk _0480_ vssd1 vssd1 vccd1 vccd1 u_core.u_regfile.rf\[24\]\[17\]
+ sky130_fd_sc_hd__dfxtp_1
XPHY_143 vssd1 vssd1 vccd1 vccd1 sky130_fd_sc_hd__decap_3
XPHY_110 vssd1 vssd1 vccd1 vccd1 sky130_fd_sc_hd__decap_3
XPHY_121 vssd1 vssd1 vccd1 vccd1 sky130_fd_sc_hd__decap_3
XPHY_132 vssd1 vssd1 vccd1 vccd1 sky130_fd_sc_hd__decap_3
XPHY_165 vssd1 vssd1 vccd1 vccd1 sky130_fd_sc_hd__decap_3
XPHY_154 vssd1 vssd1 vccd1 vccd1 sky130_fd_sc_hd__decap_3
XFILLER_0_81_335 vssd1 vssd1 vccd1 vccd1 sky130_fd_sc_hd__fill_1
XFILLER_0_1_329 vssd1 vssd1 vccd1 vccd1 sky130_fd_sc_hd__decap_6
XFILLER_0_76_118 vssd1 vssd1 vccd1 vccd1 sky130_fd_sc_hd__fill_1
X_3981_ _1986_ vssd1 vssd1 vccd1 vccd1 _0453_ sky130_fd_sc_hd__clkbuf_1
XPHY_1 vssd1 vssd1 vccd1 vccd1 sky130_fd_sc_hd__decap_3
X_2932_ _1221_ _1223_ _1368_ vssd1 vssd1 vccd1 vccd1 _1390_ sky130_fd_sc_hd__o21ai_1
XFILLER_0_69_192 vssd1 vssd1 vccd1 vccd1 sky130_fd_sc_hd__decap_3
Xclkbuf_leaf_42_clk clknet_2_1__leaf_clk vssd1 vssd1 vccd1 vccd1 clknet_leaf_42_clk
+ sky130_fd_sc_hd__clkbuf_16
XFILLER_0_45_505 vssd1 vssd1 vccd1 vccd1 sky130_fd_sc_hd__decap_4
XFILLER_0_84_195 vssd1 vssd1 vccd1 vccd1 sky130_fd_sc_hd__fill_1
X_2863_ _0913_ u_core.u_regfile.rf\[1\]\[31\] _1133_ _0914_ vssd1 vssd1 vccd1 vccd1
+ _1321_ sky130_fd_sc_hd__a31o_1
X_4602_ clknet_leaf_3_clk _0403_ vssd1 vssd1 vccd1 vccd1 u_core.u_regfile.rf\[1\]\[4\]
+ sky130_fd_sc_hd__dfxtp_1
X_2794_ u_core.u_regfile.rf\[31\]\[23\] _0895_ _0745_ _0715_ vssd1 vssd1 vccd1 vccd1
+ _1252_ sky130_fd_sc_hd__o22a_1
X_4533_ clknet_leaf_37_clk _0334_ vssd1 vssd1 vccd1 vccd1 u_core.u_regfile.rf\[2\]\[31\]
+ sky130_fd_sc_hd__dfxtp_1
Xhold303 u_core.u_regfile.rf\[6\]\[19\] vssd1 vssd1 vccd1 vccd1 net336 sky130_fd_sc_hd__dlygate4sd3_1
XFILLER_0_4_189 vssd1 vssd1 vccd1 vccd1 sky130_fd_sc_hd__fill_1
Xhold325 u_core.u_regfile.rf\[24\]\[23\] vssd1 vssd1 vccd1 vccd1 net358 sky130_fd_sc_hd__dlygate4sd3_1
Xhold314 u_core.u_regfile.rf\[2\]\[19\] vssd1 vssd1 vccd1 vccd1 net347 sky130_fd_sc_hd__dlygate4sd3_1
Xhold336 u_core.u_regfile.rf\[1\]\[12\] vssd1 vssd1 vccd1 vccd1 net369 sky130_fd_sc_hd__dlygate4sd3_1
XFILLER_0_7_55 vssd1 vssd1 vccd1 vccd1 sky130_fd_sc_hd__fill_1
X_4464_ clknet_leaf_1_clk _0265_ vssd1 vssd1 vccd1 vccd1 u_core.u_regfile.rf\[7\]\[26\]
+ sky130_fd_sc_hd__dfxtp_1
Xhold369 u_core.u_regfile.rf\[29\]\[25\] vssd1 vssd1 vccd1 vccd1 net402 sky130_fd_sc_hd__dlygate4sd3_1
Xhold347 u_core.u_regfile.rf\[1\]\[24\] vssd1 vssd1 vccd1 vccd1 net380 sky130_fd_sc_hd__dlygate4sd3_1
Xhold358 u_core.u_regfile.rf\[29\]\[6\] vssd1 vssd1 vccd1 vccd1 net391 sky130_fd_sc_hd__dlygate4sd3_1
X_4395_ clknet_leaf_13_clk _0206_ net24 vssd1 vssd1 vccd1 vccd1 u_timer.threshold_reg\[31\]
+ sky130_fd_sc_hd__dfrtp_1
X_3415_ net11 vssd1 vssd1 vccd1 vccd1 _1695_ sky130_fd_sc_hd__buf_2
X_3346_ net429 vssd1 vssd1 vccd1 vccd1 _1664_ sky130_fd_sc_hd__clkbuf_1
XTAP_630 vssd1 vccd1 sky130_fd_sc_hd__tapvpwrvgnd_1
XTAP_641 vssd1 vccd1 sky130_fd_sc_hd__tapvpwrvgnd_1
XTAP_652 vssd1 vccd1 sky130_fd_sc_hd__tapvpwrvgnd_1
XTAP_663 vssd1 vccd1 sky130_fd_sc_hd__tapvpwrvgnd_1
XTAP_674 vssd1 vccd1 sky130_fd_sc_hd__tapvpwrvgnd_1
XTAP_685 vssd1 vccd1 sky130_fd_sc_hd__tapvpwrvgnd_1
XFILLER_0_30_3 vssd1 vssd1 vccd1 vccd1 sky130_fd_sc_hd__fill_1
X_3277_ _1629_ _1630_ _1631_ net108 vssd1 vssd1 vccd1 vccd1 _0104_ sky130_fd_sc_hd__o31a_1
XTAP_696 vssd1 vccd1 sky130_fd_sc_hd__tapvpwrvgnd_1
X_2228_ u_imem.addr\[3\] vssd1 vssd1 vccd1 vccd1 _0686_ sky130_fd_sc_hd__inv_2
X_2159_ u_timer.count_reg\[14\] _0616_ u_timer.count_reg\[13\] _0617_ vssd1 vssd1
+ vccd1 vccd1 _0618_ sky130_fd_sc_hd__o22a_1
Xclkbuf_leaf_33_clk clknet_2_1__leaf_clk vssd1 vssd1 vccd1 vccd1 clknet_leaf_33_clk
+ sky130_fd_sc_hd__clkbuf_16
XFILLER_0_48_365 vccd1 vssd1 vccd1 vssd1 sky130_ef_sc_hd__decap_12
XFILLER_0_8_451 vssd1 vssd1 vccd1 vccd1 sky130_fd_sc_hd__fill_1
XFILLER_0_39_387 vssd1 vssd1 vccd1 vccd1 sky130_fd_sc_hd__decap_4
Xclkbuf_leaf_24_clk clknet_2_3__leaf_clk vssd1 vssd1 vccd1 vccd1 clknet_leaf_24_clk
+ sky130_fd_sc_hd__clkbuf_16
XFILLER_0_81_121 vssd1 vssd1 vccd1 vccd1 sky130_fd_sc_hd__decap_3
XFILLER_0_81_165 vssd1 vssd1 vccd1 vccd1 sky130_fd_sc_hd__decap_3
XFILLER_0_42_508 vssd1 vssd1 vccd1 vccd1 sky130_fd_sc_hd__fill_2
XFILLER_0_1_148 vssd1 vssd1 vccd1 vccd1 sky130_fd_sc_hd__decap_4
XFILLER_0_1_137 vssd1 vssd1 vccd1 vccd1 sky130_fd_sc_hd__decap_3
X_3200_ _1601_ vssd1 vssd1 vccd1 vccd1 _0057_ sky130_fd_sc_hd__clkbuf_1
X_4180_ net173 vssd1 vssd1 vccd1 vccd1 _2090_ sky130_fd_sc_hd__clkbuf_1
X_3131_ u_timer.count_reg\[27\] u_timer.count_reg\[26\] _1546_ u_timer.count_reg\[28\]
+ vssd1 vssd1 vccd1 vccd1 _1556_ sky130_fd_sc_hd__a31o_1
XFILLER_0_38_55 vccd1 vssd1 vccd1 vssd1 sky130_ef_sc_hd__decap_12
X_3062_ _1507_ vssd1 vssd1 vccd1 vccd1 _0036_ sky130_fd_sc_hd__clkbuf_1
XFILLER_0_77_427 vccd1 vssd1 vccd1 vssd1 sky130_ef_sc_hd__decap_12
Xclkbuf_leaf_15_clk clknet_2_2__leaf_clk vssd1 vssd1 vccd1 vccd1 clknet_leaf_15_clk
+ sky130_fd_sc_hd__clkbuf_16
X_3964_ net344 vssd1 vssd1 vccd1 vccd1 _1978_ sky130_fd_sc_hd__clkbuf_1
X_3895_ _1943_ vssd1 vssd1 vccd1 vccd1 _0410_ sky130_fd_sc_hd__clkbuf_1
XFILLER_0_45_335 vssd1 vssd1 vccd1 vccd1 sky130_fd_sc_hd__fill_1
X_2915_ _0847_ vssd1 vssd1 vccd1 vccd1 _1373_ sky130_fd_sc_hd__inv_2
XFILLER_0_33_508 vssd1 vssd1 vccd1 vccd1 sky130_fd_sc_hd__fill_2
X_2846_ _0759_ vssd1 vssd1 vccd1 vccd1 _1304_ sky130_fd_sc_hd__clkbuf_4
XFILLER_0_70_97 vssd1 vssd1 vccd1 vccd1 sky130_fd_sc_hd__decap_8
XFILLER_0_79_51 vssd1 vssd1 vccd1 vccd1 sky130_fd_sc_hd__decap_4
XFILLER_0_78_3 vccd1 vssd1 vccd1 vssd1 sky130_ef_sc_hd__decap_12
Xhold100 u_core.u_regfile.rf\[6\]\[3\] vssd1 vssd1 vccd1 vccd1 net133 sky130_fd_sc_hd__dlygate4sd3_1
X_2777_ _0771_ _0774_ _0879_ u_core.u_regfile.rf\[5\]\[21\] _1234_ vssd1 vssd1 vccd1
+ vccd1 _1235_ sky130_fd_sc_hd__o221ai_4
X_4516_ clknet_leaf_35_clk _0317_ vssd1 vssd1 vccd1 vccd1 u_core.u_regfile.rf\[2\]\[14\]
+ sky130_fd_sc_hd__dfxtp_1
Xhold122 u_core.u_regfile.rf\[3\]\[5\] vssd1 vssd1 vccd1 vccd1 net155 sky130_fd_sc_hd__dlygate4sd3_1
Xhold111 u_core.u_regfile.rf\[3\]\[0\] vssd1 vssd1 vccd1 vccd1 net144 sky130_fd_sc_hd__dlygate4sd3_1
Xhold133 u_core.u_regfile.rf\[26\]\[12\] vssd1 vssd1 vccd1 vccd1 net166 sky130_fd_sc_hd__dlygate4sd3_1
Xhold144 u_core.u_regfile.rf\[30\]\[0\] vssd1 vssd1 vccd1 vccd1 net177 sky130_fd_sc_hd__dlygate4sd3_1
X_4447_ clknet_leaf_0_clk _0248_ vssd1 vssd1 vccd1 vccd1 u_core.u_regfile.rf\[7\]\[9\]
+ sky130_fd_sc_hd__dfxtp_1
Xhold155 u_core.u_regfile.rf\[25\]\[20\] vssd1 vssd1 vccd1 vccd1 net188 sky130_fd_sc_hd__dlygate4sd3_1
Xhold177 u_core.u_regfile.rf\[27\]\[21\] vssd1 vssd1 vccd1 vccd1 net210 sky130_fd_sc_hd__dlygate4sd3_1
Xhold166 u_core.u_regfile.rf\[24\]\[4\] vssd1 vssd1 vccd1 vccd1 net199 sky130_fd_sc_hd__dlygate4sd3_1
Xhold199 u_core.u_regfile.rf\[3\]\[30\] vssd1 vssd1 vccd1 vccd1 net232 sky130_fd_sc_hd__dlygate4sd3_1
Xhold188 u_core.u_regfile.rf\[24\]\[11\] vssd1 vssd1 vccd1 vccd1 net221 sky130_fd_sc_hd__dlygate4sd3_1
X_4378_ clknet_leaf_20_clk _0189_ net30 vssd1 vssd1 vccd1 vccd1 u_timer.threshold_reg\[14\]
+ sky130_fd_sc_hd__dfrtp_1
XTAP_460 vssd1 vccd1 sky130_fd_sc_hd__tapvpwrvgnd_1
X_3329_ _1655_ vssd1 vssd1 vccd1 vccd1 _0132_ sky130_fd_sc_hd__clkbuf_1
XTAP_471 vssd1 vccd1 sky130_fd_sc_hd__tapvpwrvgnd_1
XTAP_482 vssd1 vccd1 sky130_fd_sc_hd__tapvpwrvgnd_1
XTAP_493 vssd1 vccd1 sky130_fd_sc_hd__tapvpwrvgnd_1
XFILLER_0_36_302 vssd1 vssd1 vccd1 vccd1 sky130_fd_sc_hd__decap_6
XFILLER_0_24_24 vssd1 vssd1 vccd1 vccd1 sky130_fd_sc_hd__decap_4
XFILLER_0_24_57 vssd1 vssd1 vccd1 vccd1 sky130_fd_sc_hd__fill_1
XFILLER_0_59_449 vssd1 vssd1 vccd1 vccd1 sky130_fd_sc_hd__fill_2
XFILLER_0_74_419 vssd1 vssd1 vccd1 vccd1 sky130_fd_sc_hd__fill_1
XFILLER_0_6_207 vssd1 vssd1 vccd1 vccd1 sky130_fd_sc_hd__decap_6
XFILLER_0_15_508 vssd1 vssd1 vccd1 vccd1 sky130_fd_sc_hd__fill_2
X_2700_ u_core.u_regfile.rf\[31\]\[19\] _0727_ _1153_ _1157_ _0739_ vssd1 vssd1 vccd1
+ vccd1 _1158_ sky130_fd_sc_hd__o221ai_4
X_3680_ _1832_ vssd1 vssd1 vccd1 vccd1 _0306_ sky130_fd_sc_hd__clkbuf_1
X_2631_ _0757_ net20 u_core.u_regfile.rf\[6\]\[4\] vssd1 vssd1 vccd1 vccd1 _1089_
+ sky130_fd_sc_hd__o21ai_1
XFILLER_0_2_413 vssd1 vssd1 vccd1 vccd1 sky130_fd_sc_hd__decap_6
XFILLER_0_2_457 vccd1 vssd1 vccd1 vssd1 sky130_ef_sc_hd__decap_12
X_2562_ _0779_ _1009_ _1014_ _1019_ vssd1 vssd1 vccd1 vccd1 _1020_ sky130_fd_sc_hd__o31a_1
X_4301_ clknet_leaf_44_clk _0112_ vssd1 vssd1 vccd1 vccd1 u_core.u_regfile.rf\[4\]\[1\]
+ sky130_fd_sc_hd__dfxtp_1
X_2493_ _0944_ _0945_ _0950_ vssd1 vssd1 vccd1 vccd1 _0951_ sky130_fd_sc_hd__a21oi_2
X_4232_ clknet_leaf_7_clk _0047_ vssd1 vssd1 vccd1 vccd1 u_core.u_regfile.rf\[31\]\[0\]
+ sky130_fd_sc_hd__dfxtp_1
XFILLER_0_4_23 vssd1 vssd1 vccd1 vccd1 sky130_fd_sc_hd__fill_2
Xclkbuf_leaf_4_clk clknet_2_0__leaf_clk vssd1 vssd1 vccd1 vccd1 clknet_leaf_4_clk
+ sky130_fd_sc_hd__clkbuf_16
X_4163_ _2081_ vssd1 vssd1 vccd1 vccd1 _0540_ sky130_fd_sc_hd__clkbuf_1
X_3114_ net468 u_timer.count_reg\[22\] _1541_ _1543_ _0001_ vssd1 vssd1 vccd1 vccd1
+ _0022_ sky130_fd_sc_hd__a311oi_1
XFILLER_0_4_89 vssd1 vssd1 vccd1 vccd1 sky130_fd_sc_hd__fill_1
X_4094_ net253 vssd1 vssd1 vccd1 vccd1 _2043_ sky130_fd_sc_hd__clkbuf_1
XFILLER_0_65_53 vssd1 vssd1 vccd1 vccd1 sky130_fd_sc_hd__decap_3
X_3045_ _0684_ vssd1 vssd1 vccd1 vccd1 _1495_ sky130_fd_sc_hd__buf_2
XFILLER_0_65_408 vccd1 vssd1 vccd1 vssd1 sky130_ef_sc_hd__decap_12
XFILLER_0_45_110 vssd1 vssd1 vccd1 vccd1 sky130_fd_sc_hd__fill_2
X_3947_ _1969_ vssd1 vssd1 vccd1 vccd1 _0436_ sky130_fd_sc_hd__clkbuf_1
XFILLER_0_5_240 vccd1 vssd1 vccd1 vssd1 sky130_ef_sc_hd__decap_12
X_3878_ net539 vssd1 vssd1 vccd1 vccd1 _1935_ sky130_fd_sc_hd__clkbuf_1
X_2829_ _0876_ _0878_ _1185_ _1189_ vssd1 vssd1 vccd1 vccd1 _1287_ sky130_fd_sc_hd__o211ai_1
XFILLER_0_60_179 vssd1 vssd1 vccd1 vccd1 sky130_fd_sc_hd__decap_6
XFILLER_0_41_393 vssd1 vssd1 vccd1 vccd1 sky130_fd_sc_hd__fill_2
XTAP_290 vssd1 vccd1 sky130_fd_sc_hd__tapvpwrvgnd_1
XFILLER_0_56_419 vssd1 vssd1 vccd1 vccd1 sky130_fd_sc_hd__fill_1
XFILLER_0_36_121 vssd1 vssd1 vccd1 vccd1 sky130_fd_sc_hd__decap_3
XFILLER_0_24_305 vssd1 vssd1 vccd1 vccd1 sky130_fd_sc_hd__decap_3
XFILLER_0_51_113 vssd1 vssd1 vccd1 vccd1 sky130_fd_sc_hd__fill_2
XFILLER_0_64_474 vssd1 vssd1 vccd1 vccd1 sky130_fd_sc_hd__fill_2
XFILLER_0_10_15 vccd1 vssd1 vccd1 vssd1 sky130_ef_sc_hd__decap_12
XFILLER_0_51_146 vssd1 vssd1 vccd1 vccd1 sky130_fd_sc_hd__fill_1
XFILLER_0_19_35 vssd1 vssd1 vccd1 vccd1 sky130_fd_sc_hd__fill_1
XFILLER_0_74_216 vssd1 vssd1 vccd1 vccd1 sky130_fd_sc_hd__decap_3
XFILLER_0_7_505 vssd1 vssd1 vccd1 vccd1 sky130_fd_sc_hd__decap_4
X_3801_ _1868_ _1388_ _1389_ _1896_ vssd1 vssd1 vccd1 vccd1 _0363_ sky130_fd_sc_hd__o31ai_1
XFILLER_0_51_77 vssd1 vssd1 vccd1 vccd1 sky130_fd_sc_hd__fill_1
XFILLER_0_55_441 vssd1 vssd1 vccd1 vccd1 sky130_fd_sc_hd__fill_1
X_4781_ clknet_leaf_27_clk _0549_ vssd1 vssd1 vccd1 vccd1 u_core.u_regfile.rf\[3\]\[14\]
+ sky130_fd_sc_hd__dfxtp_1
X_3732_ _1858_ vssd1 vssd1 vccd1 vccd1 _0332_ sky130_fd_sc_hd__clkbuf_1
X_3663_ net338 vssd1 vssd1 vccd1 vccd1 _1824_ sky130_fd_sc_hd__clkbuf_1
XFILLER_0_2_221 vssd1 vssd1 vccd1 vccd1 sky130_fd_sc_hd__decap_8
X_2614_ _1071_ _0965_ _1019_ vssd1 vssd1 vccd1 vccd1 _1072_ sky130_fd_sc_hd__and3_1
XFILLER_0_70_477 vccd1 vssd1 vccd1 vssd1 sky130_ef_sc_hd__decap_12
XFILLER_0_2_265 vccd1 vssd1 vccd1 vssd1 sky130_ef_sc_hd__decap_12
X_3594_ _1794_ _1795_ _1793_ net76 vssd1 vssd1 vccd1 vccd1 _0257_ sky130_fd_sc_hd__o31a_1
X_2545_ u_core.u_regfile.rf\[5\]\[12\] _0694_ _0883_ _0724_ _1002_ vssd1 vssd1 vccd1
+ vccd1 _1003_ sky130_fd_sc_hd__o2111ai_4
XFILLER_0_76_41 vccd1 vssd1 vccd1 vssd1 sky130_ef_sc_hd__decap_12
X_2476_ _0779_ _0933_ _0931_ vssd1 vssd1 vccd1 vccd1 _0934_ sky130_fd_sc_hd__o21bai_1
XFILLER_0_76_85 vccd1 vssd1 vccd1 vssd1 sky130_ef_sc_hd__decap_12
X_4215_ _2107_ vssd1 vssd1 vccd1 vccd1 _0566_ sky130_fd_sc_hd__clkbuf_1
X_4146_ net521 _2062_ _2072_ _2061_ vssd1 vssd1 vccd1 vccd1 _0532_ sky130_fd_sc_hd__o2bb2ai_1
X_4077_ _2034_ vssd1 vssd1 vccd1 vccd1 _0501_ sky130_fd_sc_hd__clkbuf_1
X_3028_ _0778_ _1483_ net91 vssd1 vssd1 vccd1 vccd1 _0004_ sky130_fd_sc_hd__a21oi_1
XFILLER_0_38_419 vssd1 vssd1 vccd1 vccd1 sky130_fd_sc_hd__fill_1
XFILLER_0_18_110 vssd1 vssd1 vccd1 vccd1 sky130_fd_sc_hd__fill_2
XFILLER_0_18_132 vssd1 vssd1 vccd1 vccd1 sky130_fd_sc_hd__fill_1
XFILLER_0_33_102 vssd1 vssd1 vccd1 vccd1 sky130_fd_sc_hd__decap_6
XFILLER_0_46_474 vssd1 vssd1 vccd1 vccd1 sky130_fd_sc_hd__fill_2
XFILLER_0_61_411 vssd1 vssd1 vccd1 vccd1 sky130_fd_sc_hd__fill_2
XFILLER_0_33_113 vccd1 vssd1 vccd1 vssd1 sky130_ef_sc_hd__decap_12
XFILLER_0_37_452 vssd1 vssd1 vccd1 vccd1 sky130_fd_sc_hd__fill_1
XFILLER_0_24_113 vssd1 vssd1 vccd1 vccd1 sky130_fd_sc_hd__fill_1
X_2330_ u_core.u_regfile.rf\[31\]\[28\] _0728_ _0783_ _0717_ _0787_ vssd1 vssd1 vccd1
+ vccd1 _0788_ sky130_fd_sc_hd__o221ai_4
X_2261_ u_core.u_regfile.rf\[28\]\[29\] _0698_ _0701_ _0703_ _0718_ vssd1 vssd1 vccd1
+ vccd1 _0719_ sky130_fd_sc_hd__a221o_1
X_4000_ net234 vssd1 vssd1 vccd1 vccd1 _1996_ sky130_fd_sc_hd__clkbuf_1
X_2192_ u_timer.count_reg\[6\] _0635_ u_timer.count_reg\[5\] _0637_ _0650_ vssd1 vssd1
+ vccd1 vccd1 _0651_ sky130_fd_sc_hd__o221ai_1
XFILLER_0_46_77 vssd1 vssd1 vccd1 vccd1 sky130_fd_sc_hd__fill_1
XFILLER_0_75_503 vssd1 vssd1 vccd1 vccd1 sky130_fd_sc_hd__fill_1
XFILLER_0_1_57 vccd1 vssd1 vccd1 vssd1 sky130_ef_sc_hd__decap_12
X_4764_ clknet_leaf_14_clk _0030_ net25 vssd1 vssd1 vccd1 vccd1 u_timer.count_reg\[30\]
+ sky130_fd_sc_hd__dfrtp_1
X_3715_ net140 vssd1 vssd1 vccd1 vccd1 _1850_ sky130_fd_sc_hd__clkbuf_1
X_4695_ clknet_leaf_38_clk _0496_ vssd1 vssd1 vccd1 vccd1 u_core.u_regfile.rf\[25\]\[1\]
+ sky130_fd_sc_hd__dfxtp_1
X_3646_ _1815_ vssd1 vssd1 vccd1 vccd1 _0289_ sky130_fd_sc_hd__clkbuf_1
X_3577_ _1632_ _1633_ _1790_ net129 vssd1 vssd1 vccd1 vccd1 _0245_ sky130_fd_sc_hd__o31a_1
XFILLER_0_30_149 vssd1 vssd1 vccd1 vccd1 sky130_fd_sc_hd__fill_1
XFILLER_0_60_3 vccd1 vssd1 vccd1 vssd1 sky130_ef_sc_hd__decap_12
X_2528_ _0731_ _0954_ u_core.u_regfile.rf\[28\]\[11\] vssd1 vssd1 vccd1 vccd1 _0986_
+ sky130_fd_sc_hd__o21a_1
X_2459_ _0776_ _0738_ _0741_ vssd1 vssd1 vccd1 vccd1 _0917_ sky130_fd_sc_hd__or3_1
Xhold26 u_core.u_regfile.rf\[28\]\[4\] vssd1 vssd1 vccd1 vccd1 net59 sky130_fd_sc_hd__dlygate4sd3_1
Xhold37 u_core.u_regfile.rf\[28\]\[3\] vssd1 vssd1 vccd1 vccd1 net70 sky130_fd_sc_hd__dlygate4sd3_1
Xhold15 u_core.u_regfile.rf\[5\]\[25\] vssd1 vssd1 vccd1 vccd1 net48 sky130_fd_sc_hd__dlygate4sd3_1
Xhold48 u_core.u_regfile.rf\[6\]\[4\] vssd1 vssd1 vccd1 vccd1 net81 sky130_fd_sc_hd__dlygate4sd3_1
Xhold59 u_core.u_regfile.rf\[6\]\[21\] vssd1 vssd1 vccd1 vccd1 net92 sky130_fd_sc_hd__dlygate4sd3_1
X_4129_ _1470_ _1471_ _1416_ _1677_ net15 vssd1 vssd1 vccd1 vccd1 _2061_ sky130_fd_sc_hd__o2111ai_4
XFILLER_0_78_363 vssd1 vssd1 vccd1 vccd1 sky130_fd_sc_hd__fill_1
XFILLER_0_38_205 vssd1 vssd1 vccd1 vccd1 sky130_fd_sc_hd__decap_8
XFILLER_0_19_430 vccd1 vssd1 vccd1 vssd1 sky130_ef_sc_hd__decap_12
XFILLER_0_34_411 vssd1 vssd1 vccd1 vccd1 sky130_fd_sc_hd__decap_8
XFILLER_0_34_477 vccd1 vssd1 vccd1 vssd1 sky130_ef_sc_hd__decap_12
XFILLER_0_57_503 vssd1 vssd1 vccd1 vccd1 sky130_fd_sc_hd__fill_1
XFILLER_0_84_377 vccd1 vssd1 vccd1 vssd1 sky130_ef_sc_hd__decap_12
XFILLER_0_4_349 vssd1 vssd1 vccd1 vccd1 sky130_fd_sc_hd__fill_1
X_3500_ _1683_ _1413_ _1713_ _1480_ _1754_ vssd1 vssd1 vccd1 vccd1 _1755_ sky130_fd_sc_hd__a41o_1
XFILLER_0_12_127 vssd1 vssd1 vccd1 vccd1 sky130_fd_sc_hd__fill_1
X_4480_ clknet_leaf_39_clk _0281_ vssd1 vssd1 vccd1 vccd1 u_core.u_regfile.rf\[30\]\[10\]
+ sky130_fd_sc_hd__dfxtp_1
XFILLER_0_52_274 vssd1 vssd1 vccd1 vccd1 sky130_fd_sc_hd__decap_4
XFILLER_0_52_285 vssd1 vssd1 vccd1 vccd1 sky130_fd_sc_hd__decap_8
Xhold518 u_core.u_regfile.rf\[31\]\[23\] vssd1 vssd1 vccd1 vccd1 net551 sky130_fd_sc_hd__dlygate4sd3_1
Xhold507 u_timer.threshold_reg\[25\] vssd1 vssd1 vccd1 vccd1 net540 sky130_fd_sc_hd__dlygate4sd3_1
Xhold529 u_timer.threshold_reg\[16\] vssd1 vssd1 vccd1 vccd1 net562 sky130_fd_sc_hd__dlygate4sd3_1
X_3431_ _0707_ _1304_ _0741_ vssd1 vssd1 vccd1 vccd1 _1707_ sky130_fd_sc_hd__or3_1
X_3362_ _1668_ _1666_ _1667_ net60 vssd1 vssd1 vccd1 vccd1 _0152_ sky130_fd_sc_hd__o31a_1
XTAP_801 vssd1 vccd1 sky130_fd_sc_hd__tapvpwrvgnd_1
XTAP_834 vssd1 vccd1 sky130_fd_sc_hd__tapvpwrvgnd_1
XTAP_823 vssd1 vccd1 sky130_fd_sc_hd__tapvpwrvgnd_1
X_2313_ _0770_ vssd1 vssd1 vccd1 vccd1 _0771_ sky130_fd_sc_hd__clkbuf_8
XTAP_812 vssd1 vccd1 sky130_fd_sc_hd__tapvpwrvgnd_1
XTAP_867 vssd1 vccd1 sky130_fd_sc_hd__tapvpwrvgnd_1
XTAP_856 vssd1 vccd1 sky130_fd_sc_hd__tapvpwrvgnd_1
XTAP_845 vssd1 vccd1 sky130_fd_sc_hd__tapvpwrvgnd_1
X_3293_ _1637_ vssd1 vssd1 vccd1 vccd1 _0114_ sky130_fd_sc_hd__clkbuf_1
XTAP_889 vssd1 vccd1 sky130_fd_sc_hd__tapvpwrvgnd_1
XTAP_878 vssd1 vccd1 sky130_fd_sc_hd__tapvpwrvgnd_1
X_2244_ _0691_ vssd1 vssd1 vccd1 vccd1 _0702_ sky130_fd_sc_hd__clkbuf_4
XFILLER_0_79_105 vssd1 vssd1 vccd1 vccd1 sky130_fd_sc_hd__decap_3
X_2175_ net475 vssd1 vssd1 vccd1 vccd1 _0634_ sky130_fd_sc_hd__inv_2
X_4747_ clknet_leaf_21_clk _0011_ net30 vssd1 vssd1 vccd1 vccd1 u_timer.count_reg\[13\]
+ sky130_fd_sc_hd__dfrtp_2
X_4678_ clknet_leaf_36_clk _0479_ vssd1 vssd1 vccd1 vccd1 u_core.u_regfile.rf\[24\]\[16\]
+ sky130_fd_sc_hd__dfxtp_1
X_3629_ net149 vssd1 vssd1 vccd1 vccd1 _1807_ sky130_fd_sc_hd__clkbuf_1
XFILLER_0_3_393 vccd1 vssd1 vccd1 vssd1 sky130_ef_sc_hd__decap_12
XFILLER_0_11_160 vssd1 vssd1 vccd1 vccd1 sky130_fd_sc_hd__decap_8
XFILLER_0_39_503 vssd1 vssd1 vccd1 vccd1 sky130_fd_sc_hd__fill_1
XPHY_100 vssd1 vssd1 vccd1 vccd1 sky130_fd_sc_hd__decap_3
XPHY_111 vssd1 vssd1 vccd1 vccd1 sky130_fd_sc_hd__decap_3
XPHY_122 vssd1 vssd1 vccd1 vccd1 sky130_fd_sc_hd__decap_3
XPHY_133 vssd1 vssd1 vccd1 vccd1 sky130_fd_sc_hd__decap_3
XPHY_166 vssd1 vssd1 vccd1 vccd1 sky130_fd_sc_hd__decap_3
XPHY_155 vssd1 vssd1 vccd1 vccd1 sky130_fd_sc_hd__decap_3
XPHY_144 vssd1 vssd1 vccd1 vccd1 sky130_fd_sc_hd__decap_3
XFILLER_0_22_403 vssd1 vssd1 vccd1 vccd1 sky130_fd_sc_hd__fill_1
XFILLER_0_27_57 vssd1 vssd1 vccd1 vccd1 sky130_fd_sc_hd__decap_6
X_3980_ net190 vssd1 vssd1 vccd1 vccd1 _1986_ sky130_fd_sc_hd__clkbuf_1
XPHY_2 vssd1 vssd1 vccd1 vccd1 sky130_fd_sc_hd__decap_3
XFILLER_0_43_45 vssd1 vssd1 vccd1 vccd1 sky130_fd_sc_hd__fill_1
XFILLER_0_57_333 vssd1 vssd1 vccd1 vccd1 sky130_fd_sc_hd__decap_3
X_2931_ _1384_ _1385_ _0852_ _1300_ vssd1 vssd1 vccd1 vccd1 _1389_ sky130_fd_sc_hd__o22a_1
XFILLER_0_84_141 vssd1 vssd1 vccd1 vccd1 sky130_fd_sc_hd__decap_4
Xclkbuf_0_clk clk vssd1 vssd1 vccd1 vccd1 clknet_0_clk sky130_fd_sc_hd__clkbuf_16
X_4601_ clknet_leaf_48_clk _0402_ vssd1 vssd1 vccd1 vccd1 u_core.u_regfile.rf\[1\]\[3\]
+ sky130_fd_sc_hd__dfxtp_1
X_2862_ u_core.u_regfile.rf\[5\]\[31\] _0876_ _0904_ _1319_ vssd1 vssd1 vccd1 vccd1
+ _1320_ sky130_fd_sc_hd__o31a_1
X_2793_ _1242_ _1243_ _1244_ vssd1 vssd1 vccd1 vccd1 _1251_ sky130_fd_sc_hd__a21o_1
XFILLER_0_25_252 vssd1 vssd1 vccd1 vccd1 sky130_fd_sc_hd__decap_4
X_4532_ clknet_leaf_38_clk _0333_ vssd1 vssd1 vccd1 vccd1 u_core.u_regfile.rf\[2\]\[30\]
+ sky130_fd_sc_hd__dfxtp_1
Xhold315 u_core.u_regfile.rf\[2\]\[13\] vssd1 vssd1 vccd1 vccd1 net348 sky130_fd_sc_hd__dlygate4sd3_1
XFILLER_0_25_296 vssd1 vssd1 vccd1 vccd1 sky130_fd_sc_hd__fill_1
Xhold326 u_core.u_regfile.rf\[3\]\[20\] vssd1 vssd1 vccd1 vccd1 net359 sky130_fd_sc_hd__dlygate4sd3_1
X_4463_ clknet_leaf_2_clk _0264_ vssd1 vssd1 vccd1 vccd1 u_core.u_regfile.rf\[7\]\[25\]
+ sky130_fd_sc_hd__dfxtp_1
Xhold304 u_core.u_regfile.rf\[24\]\[14\] vssd1 vssd1 vccd1 vccd1 net337 sky130_fd_sc_hd__dlygate4sd3_1
Xhold348 u_core.u_regfile.rf\[29\]\[10\] vssd1 vssd1 vccd1 vccd1 net381 sky130_fd_sc_hd__dlygate4sd3_1
Xhold359 u_core.u_regfile.rf\[29\]\[11\] vssd1 vssd1 vccd1 vccd1 net392 sky130_fd_sc_hd__dlygate4sd3_1
Xhold337 u_core.u_regfile.rf\[5\]\[10\] vssd1 vssd1 vccd1 vccd1 net370 sky130_fd_sc_hd__dlygate4sd3_1
X_3414_ _1332_ vssd1 vssd1 vccd1 vccd1 _1694_ sky130_fd_sc_hd__buf_2
X_4394_ clknet_leaf_13_clk _0205_ net24 vssd1 vssd1 vccd1 vccd1 u_timer.threshold_reg\[30\]
+ sky130_fd_sc_hd__dfrtp_1
XFILLER_0_21_491 vccd1 vssd1 vccd1 vssd1 sky130_ef_sc_hd__decap_12
X_3345_ _1663_ vssd1 vssd1 vccd1 vccd1 _0140_ sky130_fd_sc_hd__clkbuf_1
XTAP_620 vssd1 vccd1 sky130_fd_sc_hd__tapvpwrvgnd_1
XTAP_631 vssd1 vccd1 sky130_fd_sc_hd__tapvpwrvgnd_1
XTAP_642 vssd1 vccd1 sky130_fd_sc_hd__tapvpwrvgnd_1
XFILLER_0_84_41 vccd1 vssd1 vccd1 vssd1 sky130_ef_sc_hd__decap_12
X_3276_ _1629_ _1630_ _1631_ net109 vssd1 vssd1 vccd1 vccd1 _0103_ sky130_fd_sc_hd__o31a_1
XTAP_653 vssd1 vccd1 sky130_fd_sc_hd__tapvpwrvgnd_1
XTAP_664 vssd1 vccd1 sky130_fd_sc_hd__tapvpwrvgnd_1
XTAP_675 vssd1 vccd1 sky130_fd_sc_hd__tapvpwrvgnd_1
XTAP_686 vssd1 vccd1 sky130_fd_sc_hd__tapvpwrvgnd_1
X_2227_ u_imem.addr\[5\] vssd1 vssd1 vccd1 vccd1 _0685_ sky130_fd_sc_hd__clkinv_4
XTAP_697 vssd1 vccd1 sky130_fd_sc_hd__tapvpwrvgnd_1
XFILLER_0_84_85 vccd1 vssd1 vccd1 vssd1 sky130_ef_sc_hd__decap_12
XFILLER_0_23_3 vccd1 vssd1 vccd1 vssd1 sky130_ef_sc_hd__decap_12
X_2158_ net541 vssd1 vssd1 vccd1 vccd1 _0617_ sky130_fd_sc_hd__inv_2
XFILLER_0_48_377 vssd1 vssd1 vccd1 vccd1 sky130_fd_sc_hd__decap_6
XFILLER_0_75_196 vssd1 vssd1 vccd1 vccd1 sky130_fd_sc_hd__fill_1
XFILLER_0_75_185 vssd1 vssd1 vccd1 vccd1 sky130_fd_sc_hd__decap_3
XFILLER_0_8_474 vssd1 vssd1 vccd1 vccd1 sky130_fd_sc_hd__fill_2
XFILLER_0_51_509 vssd1 vssd1 vccd1 vccd1 sky130_fd_sc_hd__fill_1
XFILLER_0_79_491 vccd1 vssd1 vccd1 vssd1 sky130_ef_sc_hd__decap_12
XFILLER_0_13_15 vccd1 vssd1 vccd1 vssd1 sky130_ef_sc_hd__decap_12
XFILLER_0_66_141 vccd1 vssd1 vccd1 vssd1 sky130_ef_sc_hd__decap_12
XFILLER_0_54_369 vssd1 vssd1 vccd1 vccd1 sky130_fd_sc_hd__fill_1
XFILLER_0_1_105 vssd1 vssd1 vccd1 vccd1 sky130_fd_sc_hd__decap_6
X_3130_ _0597_ _0592_ _0591_ _1546_ vssd1 vssd1 vccd1 vccd1 _1555_ sky130_fd_sc_hd__or4b_1
XFILLER_0_38_67 vccd1 vssd1 vccd1 vssd1 sky130_ef_sc_hd__decap_12
X_3061_ _1505_ _1495_ _1506_ vssd1 vssd1 vccd1 vccd1 _1507_ sky130_fd_sc_hd__and3b_1
XFILLER_0_77_406 vssd1 vssd1 vccd1 vccd1 sky130_fd_sc_hd__fill_1
XFILLER_0_77_439 vssd1 vssd1 vccd1 vccd1 sky130_fd_sc_hd__decap_4
XFILLER_0_85_461 vccd1 vssd1 vccd1 vssd1 sky130_ef_sc_hd__decap_12
X_3963_ _1977_ vssd1 vssd1 vccd1 vccd1 _0444_ sky130_fd_sc_hd__clkbuf_1
X_3894_ net378 vssd1 vssd1 vccd1 vccd1 _1943_ sky130_fd_sc_hd__clkbuf_1
X_2914_ _1294_ net16 vssd1 vssd1 vccd1 vccd1 _1372_ sky130_fd_sc_hd__nor2_1
X_2845_ _0913_ u_core.u_regfile.rf\[1\]\[30\] _1133_ _0914_ vssd1 vssd1 vccd1 vccd1
+ _1303_ sky130_fd_sc_hd__a31o_1
X_4515_ clknet_leaf_37_clk _0316_ vssd1 vssd1 vccd1 vccd1 u_core.u_regfile.rf\[2\]\[13\]
+ sky130_fd_sc_hd__dfxtp_1
X_2776_ _0952_ _1232_ _0703_ _0909_ _1233_ vssd1 vssd1 vccd1 vccd1 _1234_ sky130_fd_sc_hd__a221o_1
Xhold101 u_core.u_regfile.rf\[5\]\[23\] vssd1 vssd1 vccd1 vccd1 net134 sky130_fd_sc_hd__dlygate4sd3_1
Xhold134 u_core.u_regfile.rf\[27\]\[26\] vssd1 vssd1 vccd1 vccd1 net167 sky130_fd_sc_hd__dlygate4sd3_1
Xhold123 u_core.u_regfile.rf\[26\]\[9\] vssd1 vssd1 vccd1 vccd1 net156 sky130_fd_sc_hd__dlygate4sd3_1
Xhold112 u_core.u_regfile.rf\[24\]\[10\] vssd1 vssd1 vccd1 vccd1 net145 sky130_fd_sc_hd__dlygate4sd3_1
Xhold167 u_core.u_regfile.rf\[2\]\[6\] vssd1 vssd1 vccd1 vccd1 net200 sky130_fd_sc_hd__dlygate4sd3_1
Xhold156 u_core.u_regfile.rf\[24\]\[8\] vssd1 vssd1 vccd1 vccd1 net189 sky130_fd_sc_hd__dlygate4sd3_1
X_4446_ clknet_leaf_0_clk _0247_ vssd1 vssd1 vccd1 vccd1 u_core.u_regfile.rf\[7\]\[8\]
+ sky130_fd_sc_hd__dfxtp_1
Xhold145 u_core.u_regfile.rf\[3\]\[27\] vssd1 vssd1 vccd1 vccd1 net178 sky130_fd_sc_hd__dlygate4sd3_1
Xhold189 u_core.u_regfile.rf\[27\]\[19\] vssd1 vssd1 vccd1 vccd1 net222 sky130_fd_sc_hd__dlygate4sd3_1
Xhold178 u_core.u_regfile.rf\[27\]\[7\] vssd1 vssd1 vccd1 vccd1 net211 sky130_fd_sc_hd__dlygate4sd3_1
X_4377_ clknet_leaf_20_clk _0188_ net30 vssd1 vssd1 vccd1 vccd1 u_timer.threshold_reg\[13\]
+ sky130_fd_sc_hd__dfrtp_1
X_3328_ net442 vssd1 vssd1 vccd1 vccd1 _1655_ sky130_fd_sc_hd__clkbuf_1
XTAP_450 vssd1 vccd1 sky130_fd_sc_hd__tapvpwrvgnd_1
XTAP_461 vssd1 vccd1 sky130_fd_sc_hd__tapvpwrvgnd_1
XTAP_472 vssd1 vccd1 sky130_fd_sc_hd__tapvpwrvgnd_1
XTAP_483 vssd1 vccd1 sky130_fd_sc_hd__tapvpwrvgnd_1
XTAP_494 vssd1 vccd1 sky130_fd_sc_hd__tapvpwrvgnd_1
X_3259_ _1626_ _1627_ _1628_ net73 vssd1 vssd1 vccd1 vccd1 _0089_ sky130_fd_sc_hd__o31a_1
XFILLER_0_48_174 vssd1 vssd1 vccd1 vccd1 sky130_fd_sc_hd__decap_3
XFILLER_0_48_185 vssd1 vssd1 vccd1 vccd1 sky130_fd_sc_hd__decap_4
XFILLER_0_39_130 vccd1 vssd1 vccd1 vssd1 sky130_ef_sc_hd__decap_12
XFILLER_0_82_475 vssd1 vssd1 vccd1 vccd1 sky130_fd_sc_hd__fill_1
X_2630_ _0860_ u_core.u_regfile.rf\[7\]\[4\] _0713_ vssd1 vssd1 vccd1 vccd1 _1088_
+ sky130_fd_sc_hd__nand3_1
XFILLER_0_42_306 vssd1 vssd1 vccd1 vccd1 sky130_fd_sc_hd__fill_2
XFILLER_0_42_317 vssd1 vssd1 vccd1 vccd1 sky130_fd_sc_hd__decap_4
X_2561_ _0693_ u_core.u_regfile.rf\[5\]\[3\] _0723_ _1018_ vssd1 vssd1 vccd1 vccd1
+ _1019_ sky130_fd_sc_hd__o211a_1
XFILLER_0_2_469 vssd1 vssd1 vccd1 vccd1 sky130_fd_sc_hd__decap_6
X_4300_ clknet_leaf_1_clk _0111_ vssd1 vssd1 vccd1 vccd1 u_core.u_regfile.rf\[4\]\[0\]
+ sky130_fd_sc_hd__dfxtp_1
X_2492_ _0900_ _0948_ _0949_ _0723_ vssd1 vssd1 vccd1 vccd1 _0950_ sky130_fd_sc_hd__o211a_2
X_4231_ _1562_ _1481_ _2115_ vssd1 vssd1 vccd1 vccd1 _0574_ sky130_fd_sc_hd__a21oi_1
X_4162_ net155 vssd1 vssd1 vccd1 vccd1 _2081_ sky130_fd_sc_hd__clkbuf_1
XFILLER_0_65_21 vccd1 vssd1 vccd1 vssd1 sky130_ef_sc_hd__decap_12
X_3113_ u_timer.count_reg\[22\] _1541_ u_timer.count_reg\[23\] vssd1 vssd1 vccd1 vccd1
+ _1543_ sky130_fd_sc_hd__a21oi_1
X_4093_ _2042_ vssd1 vssd1 vccd1 vccd1 _0509_ sky130_fd_sc_hd__clkbuf_1
X_3044_ u_timer.count_reg\[3\] u_timer.count_reg\[2\] u_timer.count_reg\[1\] u_timer.count_reg\[0\]
+ vssd1 vssd1 vccd1 vccd1 _1494_ sky130_fd_sc_hd__and4_1
XFILLER_0_14_80 vssd1 vssd1 vccd1 vccd1 sky130_fd_sc_hd__decap_4
X_3946_ net341 vssd1 vssd1 vccd1 vccd1 _1969_ sky130_fd_sc_hd__clkbuf_1
X_3877_ _1934_ vssd1 vssd1 vccd1 vccd1 _0401_ sky130_fd_sc_hd__clkbuf_1
XFILLER_0_60_114 vssd1 vssd1 vccd1 vccd1 sky130_fd_sc_hd__decap_4
XFILLER_0_5_252 vssd1 vssd1 vccd1 vccd1 sky130_fd_sc_hd__decap_3
X_2828_ _0736_ _1198_ _1203_ _1204_ vssd1 vssd1 vccd1 vccd1 _1286_ sky130_fd_sc_hd__nand4_1
XFILLER_0_5_274 vssd1 vssd1 vccd1 vccd1 sky130_fd_sc_hd__decap_6
X_2759_ _1215_ _0938_ _0714_ _1216_ _0909_ vssd1 vssd1 vccd1 vccd1 _1217_ sky130_fd_sc_hd__o2111ai_2
X_4429_ clknet_2_2__leaf_clk _0039_ net26 vssd1 vssd1 vccd1 vccd1 u_audio.counter\[0\]
+ sky130_fd_sc_hd__dfrtp_1
XTAP_291 vssd1 vccd1 sky130_fd_sc_hd__tapvpwrvgnd_1
XTAP_280 vssd1 vccd1 sky130_fd_sc_hd__tapvpwrvgnd_1
XFILLER_0_68_225 vssd1 vssd1 vccd1 vccd1 sky130_fd_sc_hd__fill_1
XFILLER_0_68_236 vssd1 vssd1 vccd1 vccd1 sky130_fd_sc_hd__decap_3
XFILLER_0_56_409 vssd1 vssd1 vccd1 vccd1 sky130_fd_sc_hd__decap_4
XFILLER_0_24_317 vssd1 vssd1 vccd1 vccd1 sky130_fd_sc_hd__decap_4
XFILLER_0_10_27 vssd1 vssd1 vccd1 vccd1 sky130_fd_sc_hd__fill_1
XFILLER_0_20_501 vssd1 vssd1 vccd1 vccd1 sky130_fd_sc_hd__decap_8
XFILLER_0_59_247 vssd1 vssd1 vccd1 vccd1 sky130_fd_sc_hd__fill_1
XFILLER_0_55_420 vssd1 vssd1 vccd1 vccd1 sky130_fd_sc_hd__fill_1
X_3800_ _1876_ _1877_ net110 vssd1 vssd1 vccd1 vccd1 _1896_ sky130_fd_sc_hd__o21ai_1
X_4780_ clknet_leaf_28_clk _0548_ vssd1 vssd1 vccd1 vccd1 u_core.u_regfile.rf\[3\]\[13\]
+ sky130_fd_sc_hd__dfxtp_1
X_3731_ net319 vssd1 vssd1 vccd1 vccd1 _1858_ sky130_fd_sc_hd__clkbuf_1
XFILLER_0_42_103 vssd1 vssd1 vccd1 vccd1 sky130_fd_sc_hd__fill_2
XFILLER_0_15_328 vssd1 vssd1 vccd1 vccd1 sky130_fd_sc_hd__decap_8
XFILLER_0_42_125 vssd1 vssd1 vccd1 vccd1 sky130_fd_sc_hd__decap_8
X_3662_ _1823_ vssd1 vssd1 vccd1 vccd1 _0297_ sky130_fd_sc_hd__clkbuf_1
XFILLER_0_70_489 vccd1 vssd1 vccd1 vssd1 sky130_ef_sc_hd__decap_12
X_3593_ _0720_ vssd1 vssd1 vccd1 vccd1 _1795_ sky130_fd_sc_hd__buf_2
X_2613_ _1009_ _1014_ vssd1 vssd1 vccd1 vccd1 _1071_ sky130_fd_sc_hd__nor2_1
X_2544_ _0891_ _0711_ _0715_ _0706_ vssd1 vssd1 vccd1 vccd1 _1002_ sky130_fd_sc_hd__and4_1
XFILLER_0_2_277 vccd1 vssd1 vccd1 vssd1 sky130_ef_sc_hd__decap_12
X_2475_ _0925_ _0926_ _0920_ vssd1 vssd1 vccd1 vccd1 _0933_ sky130_fd_sc_hd__a21o_1
XFILLER_0_76_53 vccd1 vssd1 vccd1 vssd1 sky130_ef_sc_hd__decap_12
X_4214_ net364 vssd1 vssd1 vccd1 vccd1 _2107_ sky130_fd_sc_hd__clkbuf_1
XFILLER_0_76_97 vccd1 vssd1 vccd1 vssd1 sky130_ef_sc_hd__decap_12
X_4145_ _1737_ _1715_ _1706_ _2071_ vssd1 vssd1 vccd1 vccd1 _2072_ sky130_fd_sc_hd__nand4_1
X_4076_ net276 vssd1 vssd1 vccd1 vccd1 _2034_ sky130_fd_sc_hd__clkbuf_1
X_3027_ _0728_ vssd1 vssd1 vccd1 vccd1 _1483_ sky130_fd_sc_hd__buf_4
XFILLER_0_46_442 vssd1 vssd1 vccd1 vccd1 sky130_fd_sc_hd__fill_1
XFILLER_0_58_280 vssd1 vssd1 vccd1 vccd1 sky130_fd_sc_hd__decap_4
X_3929_ _1960_ vssd1 vssd1 vccd1 vccd1 _0427_ sky130_fd_sc_hd__clkbuf_1
XFILLER_0_33_125 vssd1 vssd1 vccd1 vccd1 sky130_fd_sc_hd__fill_1
XFILLER_0_33_136 vssd1 vssd1 vccd1 vccd1 sky130_fd_sc_hd__fill_1
XFILLER_0_21_15 vccd1 vssd1 vccd1 vssd1 sky130_ef_sc_hd__decap_12
XFILLER_0_4_509 vssd1 vssd1 vccd1 vccd1 sky130_fd_sc_hd__fill_1
XFILLER_0_24_136 vssd1 vssd1 vccd1 vccd1 sky130_fd_sc_hd__decap_4
XFILLER_0_24_147 vssd1 vssd1 vccd1 vccd1 sky130_fd_sc_hd__fill_2
XFILLER_0_32_180 vssd1 vssd1 vccd1 vccd1 sky130_fd_sc_hd__decap_8
X_2260_ _0708_ _0712_ _0717_ vssd1 vssd1 vccd1 vccd1 _0718_ sky130_fd_sc_hd__and3_1
X_2191_ _0637_ u_timer.count_reg\[5\] _0648_ _0649_ vssd1 vssd1 vccd1 vccd1 _0650_
+ sky130_fd_sc_hd__a22o_1
XFILLER_0_1_69 vccd1 vssd1 vccd1 vssd1 sky130_ef_sc_hd__decap_12
X_4763_ clknet_leaf_14_clk _0028_ net25 vssd1 vssd1 vccd1 vccd1 u_timer.count_reg\[29\]
+ sky130_fd_sc_hd__dfrtp_1
X_4694_ clknet_leaf_40_clk _0495_ vssd1 vssd1 vccd1 vccd1 u_core.u_regfile.rf\[25\]\[0\]
+ sky130_fd_sc_hd__dfxtp_1
X_3714_ _1849_ vssd1 vssd1 vccd1 vccd1 _0323_ sky130_fd_sc_hd__clkbuf_1
X_3645_ net346 vssd1 vssd1 vccd1 vccd1 _1815_ sky130_fd_sc_hd__clkbuf_1
X_3576_ _1632_ _1633_ _1790_ net104 vssd1 vssd1 vccd1 vccd1 _0244_ sky130_fd_sc_hd__o31a_1
XFILLER_0_11_353 vssd1 vssd1 vccd1 vccd1 sky130_fd_sc_hd__decap_6
X_2527_ u_core.u_regfile.rf\[29\]\[11\] u_core.u_regfile.rf\[31\]\[11\] _0840_ vssd1
+ vssd1 vccd1 vccd1 _0985_ sky130_fd_sc_hd__mux2_1
X_2458_ _0813_ _0911_ _0912_ _0915_ vssd1 vssd1 vccd1 vccd1 _0916_ sky130_fd_sc_hd__a31oi_4
XFILLER_0_53_3 vccd1 vssd1 vccd1 vssd1 sky130_ef_sc_hd__decap_12
Xhold27 u_core.u_regfile.rf\[5\]\[9\] vssd1 vssd1 vccd1 vccd1 net60 sky130_fd_sc_hd__dlygate4sd3_1
Xhold38 u_core.u_regfile.rf\[5\]\[16\] vssd1 vssd1 vccd1 vccd1 net71 sky130_fd_sc_hd__dlygate4sd3_1
Xhold16 u_core.u_regfile.rf\[5\]\[26\] vssd1 vssd1 vccd1 vccd1 net49 sky130_fd_sc_hd__dlygate4sd3_1
Xhold49 u_core.u_regfile.rf\[7\]\[10\] vssd1 vssd1 vccd1 vccd1 net82 sky130_fd_sc_hd__dlygate4sd3_1
X_2389_ _0833_ _0846_ _0831_ vssd1 vssd1 vccd1 vccd1 _0847_ sky130_fd_sc_hd__o21ai_4
X_4128_ _0707_ _0712_ _0698_ _1419_ _1711_ vssd1 vssd1 vccd1 vccd1 _2060_ sky130_fd_sc_hd__a2111oi_1
X_4059_ _2025_ vssd1 vssd1 vccd1 vccd1 _0492_ sky130_fd_sc_hd__clkbuf_1
XFILLER_0_19_442 vssd1 vssd1 vccd1 vccd1 sky130_fd_sc_hd__fill_1
XFILLER_0_19_453 vssd1 vssd1 vccd1 vccd1 sky130_fd_sc_hd__fill_1
XFILLER_0_34_489 vssd1 vssd1 vccd1 vccd1 sky130_fd_sc_hd__decap_4
XFILLER_0_16_15 vccd1 vssd1 vccd1 vssd1 sky130_ef_sc_hd__decap_12
XFILLER_0_84_389 vccd1 vssd1 vccd1 vssd1 sky130_ef_sc_hd__decap_12
XFILLER_0_25_401 vssd1 vssd1 vccd1 vccd1 sky130_fd_sc_hd__fill_2
XFILLER_0_52_253 vccd1 vssd1 vccd1 vssd1 sky130_ef_sc_hd__decap_12
Xhold508 u_timer.threshold_reg\[13\] vssd1 vssd1 vccd1 vccd1 net541 sky130_fd_sc_hd__dlygate4sd3_1
Xhold519 u_timer.threshold_reg\[23\] vssd1 vssd1 vccd1 vccd1 net552 sky130_fd_sc_hd__dlygate4sd3_1
XFILLER_0_0_501 vssd1 vssd1 vccd1 vccd1 sky130_fd_sc_hd__decap_3
XFILLER_0_40_459 vssd1 vssd1 vccd1 vccd1 sky130_fd_sc_hd__fill_1
X_3430_ _1412_ vssd1 vssd1 vccd1 vccd1 _1706_ sky130_fd_sc_hd__clkbuf_4
X_3361_ _1405_ vssd1 vssd1 vccd1 vccd1 _1668_ sky130_fd_sc_hd__clkbuf_4
XTAP_835 vssd1 vccd1 sky130_fd_sc_hd__tapvpwrvgnd_1
XTAP_824 vssd1 vccd1 sky130_fd_sc_hd__tapvpwrvgnd_1
X_2312_ _0769_ vssd1 vssd1 vccd1 vccd1 _0770_ sky130_fd_sc_hd__clkbuf_4
XTAP_802 vssd1 vccd1 sky130_fd_sc_hd__tapvpwrvgnd_1
XTAP_813 vssd1 vccd1 sky130_fd_sc_hd__tapvpwrvgnd_1
XTAP_868 vssd1 vccd1 sky130_fd_sc_hd__tapvpwrvgnd_1
XTAP_857 vssd1 vccd1 sky130_fd_sc_hd__tapvpwrvgnd_1
XTAP_846 vssd1 vccd1 sky130_fd_sc_hd__tapvpwrvgnd_1
X_3292_ net406 vssd1 vssd1 vccd1 vccd1 _1637_ sky130_fd_sc_hd__clkbuf_1
XFILLER_0_57_55 vssd1 vssd1 vccd1 vccd1 sky130_fd_sc_hd__fill_1
XTAP_879 vssd1 vccd1 sky130_fd_sc_hd__tapvpwrvgnd_1
X_2243_ _0700_ vssd1 vssd1 vccd1 vccd1 _0701_ sky130_fd_sc_hd__clkbuf_4
X_2174_ _0624_ _0630_ _0632_ vssd1 vssd1 vccd1 vccd1 _0633_ sky130_fd_sc_hd__nand3_1
X_4746_ clknet_leaf_21_clk _0010_ net30 vssd1 vssd1 vccd1 vccd1 u_timer.count_reg\[12\]
+ sky130_fd_sc_hd__dfrtp_4
XFILLER_0_7_188 vccd1 vssd1 vccd1 vssd1 sky130_ef_sc_hd__decap_12
XFILLER_0_43_220 vssd1 vssd1 vccd1 vccd1 sky130_fd_sc_hd__decap_4
X_4677_ clknet_leaf_38_clk _0478_ vssd1 vssd1 vccd1 vccd1 u_core.u_regfile.rf\[24\]\[15\]
+ sky130_fd_sc_hd__dfxtp_1
X_3628_ _1806_ vssd1 vssd1 vccd1 vccd1 _0280_ sky130_fd_sc_hd__clkbuf_1
XFILLER_0_3_361 vccd1 vssd1 vccd1 vssd1 sky130_ef_sc_hd__decap_12
X_3559_ _1784_ vssd1 vssd1 vccd1 vccd1 _0233_ sky130_fd_sc_hd__clkbuf_1
XFILLER_0_85_109 vssd1 vssd1 vccd1 vccd1 sky130_fd_sc_hd__decap_3
XPHY_101 vssd1 vssd1 vccd1 vccd1 sky130_fd_sc_hd__decap_3
XPHY_112 vssd1 vssd1 vccd1 vccd1 sky130_fd_sc_hd__decap_3
XPHY_123 vssd1 vssd1 vccd1 vccd1 sky130_fd_sc_hd__decap_3
XPHY_134 vssd1 vssd1 vccd1 vccd1 sky130_fd_sc_hd__decap_3
XPHY_167 vssd1 vssd1 vccd1 vccd1 sky130_fd_sc_hd__decap_3
XPHY_156 vssd1 vssd1 vccd1 vccd1 sky130_fd_sc_hd__decap_3
XPHY_145 vssd1 vssd1 vccd1 vccd1 sky130_fd_sc_hd__decap_3
XFILLER_0_66_356 vssd1 vssd1 vccd1 vccd1 sky130_fd_sc_hd__decap_4
XFILLER_0_22_437 vssd1 vssd1 vccd1 vccd1 sky130_fd_sc_hd__fill_2
XFILLER_0_76_109 vssd1 vssd1 vccd1 vccd1 sky130_fd_sc_hd__decap_4
XPHY_3 vssd1 vssd1 vccd1 vccd1 sky130_fd_sc_hd__decap_3
XFILLER_0_69_161 vssd1 vssd1 vccd1 vccd1 sky130_fd_sc_hd__decap_6
XFILLER_0_9_409 vssd1 vssd1 vccd1 vccd1 sky130_fd_sc_hd__fill_2
XFILLER_0_43_57 vssd1 vssd1 vccd1 vccd1 sky130_fd_sc_hd__fill_2
XFILLER_0_57_345 vssd1 vssd1 vccd1 vccd1 sky130_fd_sc_hd__decap_4
X_2930_ _1299_ _1371_ _1386_ _1387_ vssd1 vssd1 vccd1 vccd1 _1388_ sky130_fd_sc_hd__o211a_1
XFILLER_0_84_197 vssd1 vssd1 vccd1 vccd1 sky130_fd_sc_hd__decap_6
X_4600_ clknet_leaf_44_clk _0401_ vssd1 vssd1 vccd1 vccd1 u_core.u_regfile.rf\[1\]\[2\]
+ sky130_fd_sc_hd__dfxtp_1
X_2861_ u_core.u_regfile.rf\[28\]\[31\] _0698_ _0701_ _0703_ _1318_ vssd1 vssd1 vccd1
+ vccd1 _1319_ sky130_fd_sc_hd__a221o_1
XFILLER_0_25_231 vccd1 vssd1 vccd1 vssd1 sky130_ef_sc_hd__decap_12
X_2792_ _0876_ _0878_ _1246_ _1249_ vssd1 vssd1 vccd1 vccd1 _1250_ sky130_fd_sc_hd__a2bb2o_1
X_4531_ clknet_leaf_37_clk _0332_ vssd1 vssd1 vccd1 vccd1 u_core.u_regfile.rf\[2\]\[29\]
+ sky130_fd_sc_hd__dfxtp_1
XFILLER_0_25_275 vssd1 vssd1 vccd1 vccd1 sky130_fd_sc_hd__decap_4
X_4462_ clknet_leaf_2_clk _0263_ vssd1 vssd1 vccd1 vccd1 u_core.u_regfile.rf\[7\]\[24\]
+ sky130_fd_sc_hd__dfxtp_1
Xhold316 u_core.u_regfile.rf\[27\]\[31\] vssd1 vssd1 vccd1 vccd1 net349 sky130_fd_sc_hd__dlygate4sd3_1
Xhold305 u_core.u_regfile.rf\[30\]\[27\] vssd1 vssd1 vccd1 vccd1 net338 sky130_fd_sc_hd__dlygate4sd3_1
XFILLER_0_7_57 vccd1 vssd1 vccd1 vssd1 sky130_ef_sc_hd__decap_12
Xhold349 u_core.u_regfile.rf\[1\]\[15\] vssd1 vssd1 vccd1 vccd1 net382 sky130_fd_sc_hd__dlygate4sd3_1
Xhold338 u_core.u_regfile.rf\[5\]\[6\] vssd1 vssd1 vccd1 vccd1 net371 sky130_fd_sc_hd__dlygate4sd3_1
Xhold327 u_core.u_regfile.rf\[3\]\[12\] vssd1 vssd1 vccd1 vccd1 net360 sky130_fd_sc_hd__dlygate4sd3_1
X_3413_ _1091_ _1092_ vssd1 vssd1 vccd1 vccd1 _1693_ sky130_fd_sc_hd__and2_1
X_4393_ clknet_leaf_16_clk _0204_ net27 vssd1 vssd1 vccd1 vccd1 u_timer.threshold_reg\[29\]
+ sky130_fd_sc_hd__dfrtp_1
X_3344_ net451 vssd1 vssd1 vccd1 vccd1 _1663_ sky130_fd_sc_hd__clkbuf_1
XTAP_610 vssd1 vccd1 sky130_fd_sc_hd__tapvpwrvgnd_1
XTAP_621 vssd1 vccd1 sky130_fd_sc_hd__tapvpwrvgnd_1
XTAP_632 vssd1 vccd1 sky130_fd_sc_hd__tapvpwrvgnd_1
XTAP_643 vssd1 vccd1 sky130_fd_sc_hd__tapvpwrvgnd_1
X_3275_ _1629_ _1630_ _1631_ net115 vssd1 vssd1 vccd1 vccd1 _0102_ sky130_fd_sc_hd__o31a_1
XTAP_654 vssd1 vccd1 sky130_fd_sc_hd__tapvpwrvgnd_1
XTAP_665 vssd1 vccd1 sky130_fd_sc_hd__tapvpwrvgnd_1
XTAP_676 vssd1 vccd1 sky130_fd_sc_hd__tapvpwrvgnd_1
XFILLER_0_84_53 vccd1 vssd1 vccd1 vssd1 sky130_ef_sc_hd__decap_12
X_2226_ _0684_ vssd1 vssd1 vccd1 vccd1 _0001_ sky130_fd_sc_hd__inv_2
XTAP_687 vssd1 vccd1 sky130_fd_sc_hd__tapvpwrvgnd_1
XTAP_698 vssd1 vccd1 sky130_fd_sc_hd__tapvpwrvgnd_1
XFILLER_0_84_97 vccd1 vssd1 vccd1 vssd1 sky130_ef_sc_hd__decap_12
X_2157_ u_timer.threshold_reg\[14\] vssd1 vssd1 vccd1 vccd1 _0616_ sky130_fd_sc_hd__inv_2
XFILLER_0_16_3 vccd1 vssd1 vccd1 vssd1 sky130_ef_sc_hd__decap_12
XFILLER_0_33_90 vccd1 vssd1 vccd1 vssd1 sky130_ef_sc_hd__decap_12
XFILLER_0_63_337 vssd1 vssd1 vccd1 vccd1 sky130_fd_sc_hd__decap_8
X_4729_ clknet_leaf_7_clk _0530_ net23 vssd1 vssd1 vccd1 vccd1 net6 sky130_fd_sc_hd__dfrtp_1
XFILLER_0_39_334 vssd1 vssd1 vccd1 vccd1 sky130_fd_sc_hd__fill_2
XFILLER_0_13_27 vssd1 vssd1 vccd1 vccd1 sky130_fd_sc_hd__fill_2
XFILLER_0_66_153 vssd1 vssd1 vccd1 vccd1 sky130_fd_sc_hd__decap_8
XFILLER_0_54_359 vssd1 vssd1 vccd1 vccd1 sky130_fd_sc_hd__decap_4
XFILLER_0_62_381 vssd1 vssd1 vccd1 vccd1 sky130_fd_sc_hd__fill_2
XFILLER_0_38_79 vssd1 vssd1 vccd1 vccd1 sky130_fd_sc_hd__decap_4
X_3060_ u_timer.count_reg\[6\] u_timer.count_reg\[5\] _1498_ u_timer.count_reg\[7\]
+ vssd1 vssd1 vccd1 vccd1 _1506_ sky130_fd_sc_hd__a31o_1
X_3962_ net269 vssd1 vssd1 vccd1 vccd1 _1977_ sky130_fd_sc_hd__clkbuf_1
XFILLER_0_85_473 vssd1 vssd1 vccd1 vccd1 sky130_fd_sc_hd__decap_3
X_3893_ _1942_ vssd1 vssd1 vccd1 vccd1 _0409_ sky130_fd_sc_hd__clkbuf_1
X_2913_ _1367_ _1370_ _1293_ vssd1 vssd1 vccd1 vccd1 _1371_ sky130_fd_sc_hd__a21boi_4
XFILLER_0_70_77 vssd1 vssd1 vccd1 vccd1 sky130_fd_sc_hd__decap_6
X_2844_ _0775_ _0767_ _0793_ _1301_ vssd1 vssd1 vccd1 vccd1 _1302_ sky130_fd_sc_hd__a2bb2oi_1
XFILLER_0_60_307 vssd1 vssd1 vccd1 vccd1 sky130_fd_sc_hd__fill_1
X_4514_ clknet_leaf_37_clk _0315_ vssd1 vssd1 vccd1 vccd1 u_core.u_regfile.rf\[2\]\[12\]
+ sky130_fd_sc_hd__dfxtp_1
XFILLER_0_5_478 vssd1 vssd1 vccd1 vccd1 sky130_fd_sc_hd__decap_3
X_2775_ _0758_ _0954_ u_core.u_regfile.rf\[28\]\[21\] vssd1 vssd1 vccd1 vccd1 _1233_
+ sky130_fd_sc_hd__o21a_1
Xhold113 u_core.u_regfile.rf\[27\]\[13\] vssd1 vssd1 vccd1 vccd1 net146 sky130_fd_sc_hd__dlygate4sd3_1
Xhold124 u_core.u_regfile.rf\[2\]\[16\] vssd1 vssd1 vccd1 vccd1 net157 sky130_fd_sc_hd__dlygate4sd3_1
Xhold102 u_core.u_regfile.rf\[6\]\[30\] vssd1 vssd1 vccd1 vccd1 net135 sky130_fd_sc_hd__dlygate4sd3_1
Xhold135 u_core.u_regfile.rf\[2\]\[11\] vssd1 vssd1 vccd1 vccd1 net168 sky130_fd_sc_hd__dlygate4sd3_1
X_4445_ clknet_leaf_50_clk _0246_ vssd1 vssd1 vccd1 vccd1 u_core.u_regfile.rf\[7\]\[7\]
+ sky130_fd_sc_hd__dfxtp_1
Xhold157 u_core.u_regfile.rf\[26\]\[22\] vssd1 vssd1 vccd1 vccd1 net190 sky130_fd_sc_hd__dlygate4sd3_1
Xhold168 u_core.u_regfile.rf\[27\]\[8\] vssd1 vssd1 vccd1 vccd1 net201 sky130_fd_sc_hd__dlygate4sd3_1
Xhold146 u_core.u_regfile.rf\[3\]\[15\] vssd1 vssd1 vccd1 vccd1 net179 sky130_fd_sc_hd__dlygate4sd3_1
Xhold179 u_core.u_regfile.rf\[25\]\[29\] vssd1 vssd1 vccd1 vccd1 net212 sky130_fd_sc_hd__dlygate4sd3_1
X_4376_ clknet_leaf_15_clk _0187_ net27 vssd1 vssd1 vccd1 vccd1 u_timer.threshold_reg\[12\]
+ sky130_fd_sc_hd__dfrtp_1
X_3327_ _1654_ vssd1 vssd1 vccd1 vccd1 _0131_ sky130_fd_sc_hd__clkbuf_1
XTAP_440 vssd1 vccd1 sky130_fd_sc_hd__tapvpwrvgnd_1
XTAP_451 vssd1 vccd1 sky130_fd_sc_hd__tapvpwrvgnd_1
XTAP_462 vssd1 vccd1 sky130_fd_sc_hd__tapvpwrvgnd_1
XTAP_473 vssd1 vccd1 sky130_fd_sc_hd__tapvpwrvgnd_1
XTAP_484 vssd1 vccd1 sky130_fd_sc_hd__tapvpwrvgnd_1
X_3258_ _1483_ vssd1 vssd1 vccd1 vccd1 _1628_ sky130_fd_sc_hd__buf_2
XTAP_495 vssd1 vccd1 sky130_fd_sc_hd__tapvpwrvgnd_1
X_2209_ _0664_ u_timer.threshold_reg\[21\] vssd1 vssd1 vccd1 vccd1 _0668_ sky130_fd_sc_hd__nand2_1
X_3189_ net558 vssd1 vssd1 vccd1 vccd1 _1596_ sky130_fd_sc_hd__clkbuf_1
XFILLER_0_63_178 vssd1 vssd1 vccd1 vccd1 sky130_fd_sc_hd__decap_8
XFILLER_0_5_3 vccd1 vssd1 vccd1 vssd1 sky130_ef_sc_hd__decap_12
XFILLER_0_24_15 vssd1 vssd1 vccd1 vccd1 sky130_fd_sc_hd__fill_1
Xclkbuf_2_0__f_clk clknet_0_clk vssd1 vssd1 vccd1 vccd1 clknet_2_0__leaf_clk sky130_fd_sc_hd__clkbuf_16
XFILLER_0_39_142 vssd1 vssd1 vccd1 vccd1 sky130_fd_sc_hd__decap_4
XFILLER_0_67_440 vssd1 vssd1 vccd1 vccd1 sky130_fd_sc_hd__decap_8
XFILLER_0_82_421 vccd1 vssd1 vccd1 vssd1 sky130_ef_sc_hd__decap_12
XFILLER_0_39_164 vssd1 vssd1 vccd1 vccd1 sky130_fd_sc_hd__decap_4
XFILLER_0_54_178 vssd1 vssd1 vccd1 vccd1 sky130_fd_sc_hd__decap_3
X_2560_ _0697_ _1016_ _1017_ vssd1 vssd1 vccd1 vccd1 _1018_ sky130_fd_sc_hd__o21ai_1
XFILLER_0_50_340 vssd1 vssd1 vccd1 vccd1 sky130_fd_sc_hd__decap_8
X_2491_ _0705_ _0709_ u_core.u_regfile.rf\[5\]\[9\] _0903_ vssd1 vssd1 vccd1 vccd1
+ _0949_ sky130_fd_sc_hd__a211o_1
XFILLER_0_49_78 vssd1 vssd1 vccd1 vccd1 sky130_fd_sc_hd__fill_1
X_4230_ _1134_ _1135_ net13 _1332_ net11 vssd1 vssd1 vccd1 vccd1 _2115_ sky130_fd_sc_hd__o2111a_1
X_4161_ _2080_ vssd1 vssd1 vccd1 vccd1 _0539_ sky130_fd_sc_hd__clkbuf_1
XFILLER_0_65_33 vssd1 vssd1 vccd1 vccd1 sky130_fd_sc_hd__decap_4
X_3112_ net532 _1541_ _1542_ _0001_ vssd1 vssd1 vccd1 vccd1 _0021_ sky130_fd_sc_hd__a211oi_1
X_4092_ net254 vssd1 vssd1 vccd1 vccd1 _2042_ sky130_fd_sc_hd__clkbuf_1
X_3043_ _1492_ _1493_ _0001_ vssd1 vssd1 vccd1 vccd1 _0029_ sky130_fd_sc_hd__nor3_1
XFILLER_0_77_204 vssd1 vssd1 vccd1 vccd1 sky130_fd_sc_hd__fill_2
X_3945_ _1968_ vssd1 vssd1 vccd1 vccd1 _0435_ sky130_fd_sc_hd__clkbuf_1
XFILLER_0_85_281 vccd1 vssd1 vccd1 vssd1 sky130_ef_sc_hd__decap_12
XFILLER_0_18_348 vssd1 vssd1 vccd1 vccd1 sky130_fd_sc_hd__decap_8
X_3876_ net405 vssd1 vssd1 vccd1 vccd1 _1934_ sky130_fd_sc_hd__clkbuf_1
XFILLER_0_45_167 vssd1 vssd1 vccd1 vccd1 sky130_fd_sc_hd__fill_1
XFILLER_0_60_104 vssd1 vssd1 vccd1 vccd1 sky130_fd_sc_hd__fill_2
XFILLER_0_83_3 vccd1 vssd1 vccd1 vssd1 sky130_ef_sc_hd__decap_12
X_2827_ _1173_ _1177_ vssd1 vssd1 vccd1 vccd1 _1285_ sky130_fd_sc_hd__nand2_1
X_2758_ _0938_ u_core.u_regfile.rf\[7\]\[20\] _0861_ vssd1 vssd1 vccd1 vccd1 _1216_
+ sky130_fd_sc_hd__nand3_1
X_2689_ _0735_ _1146_ _0950_ _0944_ _0951_ vssd1 vssd1 vccd1 vccd1 _1147_ sky130_fd_sc_hd__a41oi_4
X_4428_ clknet_leaf_16_clk _0002_ net27 vssd1 vssd1 vccd1 vccd1 u_audio.s_axi_bvalid
+ sky130_fd_sc_hd__dfrtp_1
X_4359_ clknet_leaf_18_clk _0170_ vssd1 vssd1 vccd1 vccd1 u_core.u_regfile.rf\[5\]\[27\]
+ sky130_fd_sc_hd__dfxtp_1
XTAP_292 vssd1 vccd1 sky130_fd_sc_hd__tapvpwrvgnd_1
XTAP_281 vssd1 vccd1 sky130_fd_sc_hd__tapvpwrvgnd_1
XTAP_270 vssd1 vccd1 sky130_fd_sc_hd__tapvpwrvgnd_1
Xfanout30 net32 vssd1 vssd1 vccd1 vccd1 net30 sky130_fd_sc_hd__clkbuf_4
XFILLER_0_51_126 vssd1 vssd1 vccd1 vccd1 sky130_fd_sc_hd__decap_4
XFILLER_0_19_15 vccd1 vssd1 vccd1 vssd1 sky130_ef_sc_hd__decap_12
XFILLER_0_59_237 vssd1 vssd1 vccd1 vccd1 sky130_fd_sc_hd__fill_2
X_3730_ _1857_ vssd1 vssd1 vccd1 vccd1 _0331_ sky130_fd_sc_hd__clkbuf_1
XFILLER_0_55_498 vssd1 vssd1 vccd1 vccd1 sky130_fd_sc_hd__fill_1
X_3661_ net322 vssd1 vssd1 vccd1 vccd1 _1823_ sky130_fd_sc_hd__clkbuf_1
XFILLER_0_70_413 vssd1 vssd1 vccd1 vccd1 sky130_fd_sc_hd__decap_6
XFILLER_0_70_424 vssd1 vssd1 vccd1 vccd1 sky130_fd_sc_hd__fill_1
X_3592_ _0707_ vssd1 vssd1 vccd1 vccd1 _1794_ sky130_fd_sc_hd__buf_2
X_2612_ _1050_ _1068_ _1069_ vssd1 vssd1 vccd1 vccd1 _1070_ sky130_fd_sc_hd__a21oi_2
XFILLER_0_23_373 vssd1 vssd1 vccd1 vccd1 sky130_fd_sc_hd__decap_3
X_2543_ _0780_ _0931_ _0920_ _0927_ vssd1 vssd1 vccd1 vccd1 _1001_ sky130_fd_sc_hd__or4_2
XFILLER_0_2_289 vccd1 vssd1 vccd1 vssd1 sky130_ef_sc_hd__decap_12
X_2474_ _0876_ _0878_ _0931_ vssd1 vssd1 vccd1 vccd1 _0932_ sky130_fd_sc_hd__o21ai_1
XFILLER_0_76_65 vccd1 vssd1 vccd1 vssd1 sky130_ef_sc_hd__decap_12
X_4213_ _2106_ vssd1 vssd1 vccd1 vccd1 _0565_ sky130_fd_sc_hd__clkbuf_1
X_4144_ _1304_ _0712_ u_core.u_regfile.rf\[31\]\[5\] net19 _1085_ vssd1 vssd1 vccd1
+ vccd1 _2071_ sky130_fd_sc_hd__o311a_1
X_4075_ _2033_ vssd1 vssd1 vccd1 vccd1 _0500_ sky130_fd_sc_hd__clkbuf_1
X_3026_ _1482_ net91 vssd1 vssd1 vccd1 vccd1 _0003_ sky130_fd_sc_hd__nor2_1
XFILLER_0_46_421 vssd1 vssd1 vccd1 vccd1 sky130_fd_sc_hd__decap_4
XFILLER_0_46_454 vssd1 vssd1 vccd1 vccd1 sky130_fd_sc_hd__fill_1
X_3928_ net463 vssd1 vssd1 vccd1 vccd1 _1960_ sky130_fd_sc_hd__clkbuf_1
X_3859_ _1925_ vssd1 vssd1 vccd1 vccd1 _0392_ sky130_fd_sc_hd__clkbuf_1
XFILLER_0_61_446 vssd1 vssd1 vccd1 vccd1 sky130_fd_sc_hd__fill_2
XFILLER_0_14_373 vccd1 vssd1 vccd1 vssd1 sky130_ef_sc_hd__decap_12
XFILLER_0_69_502 vssd1 vssd1 vccd1 vccd1 sky130_fd_sc_hd__fill_2
XFILLER_0_21_27 vssd1 vssd1 vccd1 vccd1 sky130_fd_sc_hd__decap_8
XFILLER_0_52_424 vssd1 vssd1 vccd1 vccd1 sky130_fd_sc_hd__fill_2
XFILLER_0_20_365 vssd1 vssd1 vccd1 vccd1 sky130_fd_sc_hd__fill_1
X_2190_ u_timer.count_reg\[4\] _0638_ vssd1 vssd1 vccd1 vccd1 _0649_ sky130_fd_sc_hd__or2_1
XFILLER_0_1_15 vccd1 vssd1 vccd1 vssd1 sky130_ef_sc_hd__decap_12
XFILLER_0_75_505 vssd1 vssd1 vccd1 vccd1 sky130_fd_sc_hd__decap_4
X_4762_ clknet_leaf_14_clk _0027_ net25 vssd1 vssd1 vccd1 vccd1 u_timer.count_reg\[28\]
+ sky130_fd_sc_hd__dfrtp_2
X_4693_ clknet_leaf_39_clk _0494_ vssd1 vssd1 vccd1 vccd1 u_core.u_regfile.rf\[24\]\[31\]
+ sky130_fd_sc_hd__dfxtp_1
X_3713_ net243 vssd1 vssd1 vccd1 vccd1 _1849_ sky130_fd_sc_hd__clkbuf_1
XFILLER_0_43_435 vssd1 vssd1 vccd1 vccd1 sky130_fd_sc_hd__decap_3
X_3644_ _1814_ vssd1 vssd1 vccd1 vccd1 _0288_ sky130_fd_sc_hd__clkbuf_1
X_3575_ _1632_ _1633_ _1790_ net111 vssd1 vssd1 vccd1 vccd1 _0243_ sky130_fd_sc_hd__o31a_1
XFILLER_0_11_321 vccd1 vssd1 vccd1 vssd1 sky130_ef_sc_hd__decap_12
X_2526_ _0779_ _0981_ _0982_ _0983_ vssd1 vssd1 vccd1 vccd1 _0984_ sky130_fd_sc_hd__o31ai_4
X_2457_ _0913_ u_core.u_regfile.rf\[1\]\[13\] _0858_ _0914_ vssd1 vssd1 vccd1 vccd1
+ _0915_ sky130_fd_sc_hd__a31o_1
Xhold28 u_core.u_regfile.rf\[7\]\[9\] vssd1 vssd1 vccd1 vccd1 net61 sky130_fd_sc_hd__dlygate4sd3_1
XFILLER_0_46_3 vccd1 vssd1 vccd1 vssd1 sky130_ef_sc_hd__decap_12
Xhold17 u_core.u_regfile.rf\[5\]\[27\] vssd1 vssd1 vccd1 vccd1 net50 sky130_fd_sc_hd__dlygate4sd3_1
Xhold39 u_core.u_regfile.rf\[6\]\[14\] vssd1 vssd1 vccd1 vccd1 net72 sky130_fd_sc_hd__dlygate4sd3_1
X_2388_ _0845_ vssd1 vssd1 vccd1 vccd1 _0846_ sky130_fd_sc_hd__inv_2
X_4127_ _2059_ vssd1 vssd1 vccd1 vccd1 _0526_ sky130_fd_sc_hd__clkbuf_1
X_4058_ net241 vssd1 vssd1 vccd1 vccd1 _2025_ sky130_fd_sc_hd__clkbuf_1
X_3009_ _1453_ _1457_ _1462_ _1466_ vssd1 vssd1 vccd1 vccd1 _1467_ sky130_fd_sc_hd__nand4_1
XFILLER_0_66_505 vssd1 vssd1 vccd1 vccd1 sky130_fd_sc_hd__decap_4
XFILLER_0_19_410 vssd1 vssd1 vccd1 vccd1 sky130_fd_sc_hd__fill_1
XFILLER_0_61_221 vssd1 vssd1 vccd1 vccd1 sky130_fd_sc_hd__decap_3
XFILLER_0_16_27 vssd1 vssd1 vccd1 vccd1 sky130_fd_sc_hd__fill_1
XFILLER_0_84_302 vssd1 vssd1 vccd1 vccd1 sky130_fd_sc_hd__decap_6
XFILLER_0_57_505 vssd1 vssd1 vccd1 vccd1 sky130_fd_sc_hd__decap_4
XFILLER_0_72_508 vssd1 vssd1 vccd1 vccd1 sky130_fd_sc_hd__fill_2
XFILLER_0_52_232 vssd1 vssd1 vccd1 vccd1 sky130_fd_sc_hd__decap_4
Xhold509 u_core.u_regfile.rf\[4\]\[11\] vssd1 vssd1 vccd1 vccd1 net542 sky130_fd_sc_hd__dlygate4sd3_1
XFILLER_0_40_427 vssd1 vssd1 vccd1 vccd1 sky130_fd_sc_hd__fill_1
XFILLER_0_52_265 vssd1 vssd1 vccd1 vccd1 sky130_fd_sc_hd__decap_3
X_3360_ _1482_ _1666_ _1667_ net255 vssd1 vssd1 vccd1 vccd1 _0151_ sky130_fd_sc_hd__o31a_1
XTAP_825 vssd1 vccd1 sky130_fd_sc_hd__tapvpwrvgnd_1
X_2311_ _0729_ _0686_ vssd1 vssd1 vccd1 vccd1 _0769_ sky130_fd_sc_hd__nor2_2
XTAP_803 vssd1 vccd1 sky130_fd_sc_hd__tapvpwrvgnd_1
XTAP_814 vssd1 vccd1 sky130_fd_sc_hd__tapvpwrvgnd_1
XTAP_858 vssd1 vccd1 sky130_fd_sc_hd__tapvpwrvgnd_1
XTAP_847 vssd1 vccd1 sky130_fd_sc_hd__tapvpwrvgnd_1
XTAP_836 vssd1 vccd1 sky130_fd_sc_hd__tapvpwrvgnd_1
X_3291_ _1636_ vssd1 vssd1 vccd1 vccd1 _0113_ sky130_fd_sc_hd__clkbuf_1
XTAP_869 vssd1 vccd1 sky130_fd_sc_hd__tapvpwrvgnd_1
X_2242_ _0699_ vssd1 vssd1 vccd1 vccd1 _0700_ sky130_fd_sc_hd__clkbuf_4
X_2173_ u_timer.count_reg\[9\] _0628_ u_timer.count_reg\[8\] _0627_ _0631_ vssd1 vssd1
+ vccd1 vccd1 _0632_ sky130_fd_sc_hd__o221a_1
XFILLER_0_73_55 vssd1 vssd1 vccd1 vccd1 sky130_fd_sc_hd__fill_1
Xclkbuf_leaf_45_clk clknet_2_0__leaf_clk vssd1 vssd1 vccd1 vccd1 clknet_leaf_45_clk
+ sky130_fd_sc_hd__clkbuf_16
X_4745_ clknet_leaf_21_clk _0009_ net28 vssd1 vssd1 vccd1 vccd1 u_timer.count_reg\[11\]
+ sky130_fd_sc_hd__dfrtp_4
XFILLER_0_7_167 vssd1 vssd1 vccd1 vccd1 sky130_fd_sc_hd__fill_1
XFILLER_0_31_405 vssd1 vssd1 vccd1 vccd1 sky130_fd_sc_hd__decap_4
X_4676_ clknet_leaf_27_clk _0477_ vssd1 vssd1 vccd1 vccd1 u_core.u_regfile.rf\[24\]\[14\]
+ sky130_fd_sc_hd__dfxtp_1
X_3627_ net248 vssd1 vssd1 vccd1 vccd1 _1806_ sky130_fd_sc_hd__clkbuf_1
XFILLER_0_31_449 vssd1 vssd1 vccd1 vccd1 sky130_fd_sc_hd__fill_2
XFILLER_0_43_298 vssd1 vssd1 vccd1 vccd1 sky130_fd_sc_hd__decap_8
XFILLER_0_11_140 vssd1 vssd1 vccd1 vccd1 sky130_fd_sc_hd__fill_1
XFILLER_0_3_373 vccd1 vssd1 vccd1 vssd1 sky130_ef_sc_hd__decap_12
X_3558_ net436 vssd1 vssd1 vccd1 vccd1 _1784_ sky130_fd_sc_hd__clkbuf_1
X_2509_ _0944_ _0950_ _0771_ _0706_ vssd1 vssd1 vccd1 vccd1 _0967_ sky130_fd_sc_hd__nand4_4
X_3489_ _0839_ _1741_ _1748_ vssd1 vssd1 vccd1 vccd1 _0199_ sky130_fd_sc_hd__o21ai_1
Xclkbuf_leaf_36_clk clknet_2_1__leaf_clk vssd1 vssd1 vccd1 vccd1 clknet_leaf_36_clk
+ sky130_fd_sc_hd__clkbuf_16
XFILLER_0_39_505 vssd1 vssd1 vccd1 vccd1 sky130_fd_sc_hd__fill_2
XFILLER_0_78_195 vssd1 vssd1 vccd1 vccd1 sky130_fd_sc_hd__fill_1
XPHY_102 vssd1 vssd1 vccd1 vccd1 sky130_fd_sc_hd__decap_3
XPHY_113 vssd1 vssd1 vccd1 vccd1 sky130_fd_sc_hd__decap_3
XPHY_124 vssd1 vssd1 vccd1 vccd1 sky130_fd_sc_hd__decap_3
XPHY_157 vssd1 vssd1 vccd1 vccd1 sky130_fd_sc_hd__decap_3
XPHY_146 vssd1 vssd1 vccd1 vccd1 sky130_fd_sc_hd__decap_3
XPHY_135 vssd1 vssd1 vccd1 vccd1 sky130_fd_sc_hd__decap_3
XPHY_168 vssd1 vssd1 vccd1 vccd1 sky130_fd_sc_hd__decap_3
XFILLER_0_34_243 vssd1 vssd1 vccd1 vccd1 sky130_fd_sc_hd__fill_1
Xclkbuf_leaf_27_clk clknet_2_3__leaf_clk vssd1 vssd1 vccd1 vccd1 clknet_leaf_27_clk
+ sky130_fd_sc_hd__clkbuf_16
XPHY_4 vssd1 vssd1 vccd1 vccd1 sky130_fd_sc_hd__decap_3
XFILLER_0_72_305 vssd1 vssd1 vccd1 vccd1 sky130_fd_sc_hd__decap_3
X_2860_ _1317_ _0712_ _0717_ vssd1 vssd1 vccd1 vccd1 _1318_ sky130_fd_sc_hd__and3_1
XFILLER_0_25_243 vssd1 vssd1 vccd1 vccd1 sky130_fd_sc_hd__decap_6
X_2791_ _0952_ _1247_ _0703_ _0701_ _1248_ vssd1 vssd1 vccd1 vccd1 _1249_ sky130_fd_sc_hd__a221o_1
XFILLER_0_65_390 vssd1 vssd1 vccd1 vccd1 sky130_fd_sc_hd__fill_2
XFILLER_0_80_360 vssd1 vssd1 vccd1 vccd1 sky130_fd_sc_hd__decap_4
XFILLER_0_4_137 vssd1 vssd1 vccd1 vccd1 sky130_fd_sc_hd__decap_3
X_4530_ clknet_leaf_35_clk _0331_ vssd1 vssd1 vccd1 vccd1 u_core.u_regfile.rf\[2\]\[28\]
+ sky130_fd_sc_hd__dfxtp_1
XFILLER_0_13_449 vssd1 vssd1 vccd1 vccd1 sky130_fd_sc_hd__fill_1
Xhold317 u_core.u_regfile.rf\[30\]\[22\] vssd1 vssd1 vccd1 vccd1 net350 sky130_fd_sc_hd__dlygate4sd3_1
Xhold306 u_core.u_regfile.rf\[26\]\[25\] vssd1 vssd1 vccd1 vccd1 net339 sky130_fd_sc_hd__dlygate4sd3_1
X_4461_ clknet_leaf_1_clk _0262_ vssd1 vssd1 vccd1 vccd1 u_core.u_regfile.rf\[7\]\[23\]
+ sky130_fd_sc_hd__dfxtp_1
X_3412_ _0639_ _1680_ _1692_ vssd1 vssd1 vccd1 vccd1 _0178_ sky130_fd_sc_hd__a21oi_1
XFILLER_0_7_69 vccd1 vssd1 vccd1 vssd1 sky130_ef_sc_hd__decap_12
XFILLER_0_0_321 vccd1 vssd1 vccd1 vssd1 sky130_ef_sc_hd__decap_12
Xhold328 u_core.u_regfile.rf\[25\]\[21\] vssd1 vssd1 vccd1 vccd1 net361 sky130_fd_sc_hd__dlygate4sd3_1
Xhold339 u_core.u_regfile.rf\[29\]\[9\] vssd1 vssd1 vccd1 vccd1 net372 sky130_fd_sc_hd__dlygate4sd3_1
X_4392_ clknet_leaf_13_clk _0203_ net24 vssd1 vssd1 vccd1 vccd1 u_timer.threshold_reg\[28\]
+ sky130_fd_sc_hd__dfrtp_1
XFILLER_0_21_471 vssd1 vssd1 vccd1 vccd1 sky130_fd_sc_hd__fill_1
XTAP_600 vssd1 vccd1 sky130_fd_sc_hd__tapvpwrvgnd_1
XFILLER_0_0_365 vssd1 vssd1 vccd1 vccd1 sky130_fd_sc_hd__decap_4
X_3343_ _1662_ vssd1 vssd1 vccd1 vccd1 _0139_ sky130_fd_sc_hd__clkbuf_1
XTAP_611 vssd1 vccd1 sky130_fd_sc_hd__tapvpwrvgnd_1
XTAP_622 vssd1 vccd1 sky130_fd_sc_hd__tapvpwrvgnd_1
XTAP_633 vssd1 vccd1 sky130_fd_sc_hd__tapvpwrvgnd_1
X_3274_ _1629_ _1630_ _1631_ net139 vssd1 vssd1 vccd1 vccd1 _0101_ sky130_fd_sc_hd__o31a_1
XTAP_644 vssd1 vccd1 sky130_fd_sc_hd__tapvpwrvgnd_1
XTAP_655 vssd1 vccd1 sky130_fd_sc_hd__tapvpwrvgnd_1
XTAP_666 vssd1 vccd1 sky130_fd_sc_hd__tapvpwrvgnd_1
XTAP_677 vssd1 vccd1 sky130_fd_sc_hd__tapvpwrvgnd_1
XFILLER_0_84_65 vccd1 vssd1 vccd1 vssd1 sky130_ef_sc_hd__decap_12
X_2225_ _0577_ _0578_ _0581_ _0599_ _0683_ vssd1 vssd1 vccd1 vccd1 _0684_ sky130_fd_sc_hd__o221a_2
XTAP_688 vssd1 vccd1 sky130_fd_sc_hd__tapvpwrvgnd_1
XTAP_699 vssd1 vccd1 sky130_fd_sc_hd__tapvpwrvgnd_1
X_2156_ u_timer.threshold_reg\[14\] _0613_ u_timer.threshold_reg\[15\] _0614_ vssd1
+ vssd1 vccd1 vccd1 _0615_ sky130_fd_sc_hd__o22a_1
XFILLER_0_17_92 vccd1 vssd1 vccd1 vssd1 sky130_ef_sc_hd__decap_12
Xclkbuf_leaf_18_clk clknet_2_2__leaf_clk vssd1 vssd1 vccd1 vccd1 clknet_leaf_18_clk
+ sky130_fd_sc_hd__clkbuf_16
XFILLER_0_36_508 vssd1 vssd1 vccd1 vccd1 sky130_fd_sc_hd__fill_2
XFILLER_0_16_232 vssd1 vssd1 vccd1 vccd1 sky130_fd_sc_hd__fill_1
X_2989_ _0894_ _1445_ vssd1 vssd1 vccd1 vccd1 _1447_ sky130_fd_sc_hd__or2_1
X_4728_ clknet_leaf_17_clk _0529_ net23 vssd1 vssd1 vccd1 vccd1 net5 sky130_fd_sc_hd__dfrtp_4
XFILLER_0_16_287 vssd1 vssd1 vccd1 vccd1 sky130_fd_sc_hd__fill_2
X_4659_ clknet_leaf_26_clk _0460_ vssd1 vssd1 vccd1 vccd1 u_core.u_regfile.rf\[26\]\[29\]
+ sky130_fd_sc_hd__dfxtp_1
XFILLER_0_31_279 vssd1 vssd1 vccd1 vccd1 sky130_fd_sc_hd__fill_1
XFILLER_0_27_508 vssd1 vssd1 vccd1 vccd1 sky130_fd_sc_hd__fill_2
XFILLER_0_54_305 vssd1 vssd1 vccd1 vccd1 sky130_fd_sc_hd__decap_3
XFILLER_0_47_390 vssd1 vssd1 vccd1 vccd1 sky130_fd_sc_hd__fill_2
XFILLER_0_22_224 vssd1 vssd1 vccd1 vccd1 sky130_fd_sc_hd__fill_2
X_3961_ _1976_ vssd1 vssd1 vccd1 vccd1 _0443_ sky130_fd_sc_hd__clkbuf_1
XFILLER_0_18_508 vssd1 vssd1 vccd1 vccd1 sky130_fd_sc_hd__fill_2
X_2912_ _1209_ _1272_ vssd1 vssd1 vccd1 vccd1 _1370_ sky130_fd_sc_hd__nor2_1
X_3892_ net433 vssd1 vssd1 vccd1 vccd1 _1942_ sky130_fd_sc_hd__clkbuf_1
X_2843_ _0794_ _0792_ _0852_ _1300_ vssd1 vssd1 vccd1 vccd1 _1301_ sky130_fd_sc_hd__o22ai_4
X_2774_ u_core.u_regfile.rf\[29\]\[21\] u_core.u_regfile.rf\[31\]\[21\] _0705_ vssd1
+ vssd1 vccd1 vccd1 _1232_ sky130_fd_sc_hd__mux2_1
X_4513_ clknet_leaf_25_clk _0314_ vssd1 vssd1 vccd1 vccd1 u_core.u_regfile.rf\[2\]\[11\]
+ sky130_fd_sc_hd__dfxtp_1
Xhold103 u_core.u_regfile.rf\[7\]\[11\] vssd1 vssd1 vccd1 vccd1 net136 sky130_fd_sc_hd__dlygate4sd3_1
Xhold114 u_core.u_regfile.rf\[25\]\[22\] vssd1 vssd1 vccd1 vccd1 net147 sky130_fd_sc_hd__dlygate4sd3_1
Xhold125 u_core.u_regfile.rf\[27\]\[6\] vssd1 vssd1 vccd1 vccd1 net158 sky130_fd_sc_hd__dlygate4sd3_1
Xhold136 u_core.u_regfile.rf\[24\]\[1\] vssd1 vssd1 vccd1 vccd1 net169 sky130_fd_sc_hd__dlygate4sd3_1
Xhold158 u_core.u_regfile.rf\[27\]\[14\] vssd1 vssd1 vccd1 vccd1 net191 sky130_fd_sc_hd__dlygate4sd3_1
X_4444_ clknet_leaf_1_clk _0245_ vssd1 vssd1 vccd1 vccd1 u_core.u_regfile.rf\[7\]\[6\]
+ sky130_fd_sc_hd__dfxtp_1
Xhold147 u_core.u_regfile.rf\[26\]\[29\] vssd1 vssd1 vccd1 vccd1 net180 sky130_fd_sc_hd__dlygate4sd3_1
Xclkbuf_leaf_7_clk clknet_2_2__leaf_clk vssd1 vssd1 vccd1 vccd1 clknet_leaf_7_clk
+ sky130_fd_sc_hd__clkbuf_16
Xhold169 u_core.u_regfile.rf\[2\]\[24\] vssd1 vssd1 vccd1 vccd1 net202 sky130_fd_sc_hd__dlygate4sd3_1
XFILLER_0_0_162 vssd1 vssd1 vccd1 vccd1 sky130_fd_sc_hd__decap_6
X_4375_ clknet_leaf_20_clk _0186_ net27 vssd1 vssd1 vccd1 vccd1 u_timer.threshold_reg\[11\]
+ sky130_fd_sc_hd__dfrtp_1
X_3326_ net456 vssd1 vssd1 vccd1 vccd1 _1654_ sky130_fd_sc_hd__clkbuf_1
XFILLER_0_0_184 vccd1 vssd1 vccd1 vssd1 sky130_ef_sc_hd__decap_12
XTAP_430 vssd1 vccd1 sky130_fd_sc_hd__tapvpwrvgnd_1
XTAP_441 vssd1 vccd1 sky130_fd_sc_hd__tapvpwrvgnd_1
XTAP_452 vssd1 vccd1 sky130_fd_sc_hd__tapvpwrvgnd_1
XTAP_463 vssd1 vccd1 sky130_fd_sc_hd__tapvpwrvgnd_1
XTAP_474 vssd1 vccd1 sky130_fd_sc_hd__tapvpwrvgnd_1
XTAP_485 vssd1 vccd1 sky130_fd_sc_hd__tapvpwrvgnd_1
X_3257_ _1486_ vssd1 vssd1 vccd1 vccd1 _1627_ sky130_fd_sc_hd__buf_2
XTAP_496 vssd1 vccd1 sky130_fd_sc_hd__tapvpwrvgnd_1
X_2208_ net562 vssd1 vssd1 vccd1 vccd1 _0667_ sky130_fd_sc_hd__inv_2
X_3188_ _1595_ vssd1 vssd1 vccd1 vccd1 _0051_ sky130_fd_sc_hd__clkbuf_1
X_2139_ u_timer.threshold_reg\[28\] _0597_ u_timer.threshold_reg\[29\] _0579_ vssd1
+ vssd1 vccd1 vccd1 _0598_ sky130_fd_sc_hd__o22a_1
XFILLER_0_68_419 vssd1 vssd1 vccd1 vccd1 sky130_fd_sc_hd__fill_1
XFILLER_0_48_132 vssd1 vssd1 vccd1 vccd1 sky130_fd_sc_hd__fill_2
XFILLER_0_36_316 vccd1 vssd1 vccd1 vssd1 sky130_ef_sc_hd__decap_12
XFILLER_0_8_262 vssd1 vssd1 vccd1 vccd1 sky130_fd_sc_hd__fill_1
XFILLER_0_8_251 vssd1 vssd1 vccd1 vccd1 sky130_fd_sc_hd__fill_1
XFILLER_0_79_290 vssd1 vssd1 vccd1 vccd1 sky130_fd_sc_hd__decap_3
XFILLER_0_67_430 vssd1 vssd1 vccd1 vccd1 sky130_fd_sc_hd__decap_6
XFILLER_0_67_474 vccd1 vssd1 vccd1 vssd1 sky130_ef_sc_hd__decap_12
XFILLER_0_82_433 vccd1 vssd1 vccd1 vssd1 sky130_ef_sc_hd__decap_12
XFILLER_0_40_15 vssd1 vssd1 vccd1 vccd1 sky130_fd_sc_hd__decap_4
XFILLER_0_82_477 vccd1 vssd1 vccd1 vssd1 sky130_ef_sc_hd__decap_12
XFILLER_0_35_393 vssd1 vssd1 vccd1 vccd1 sky130_fd_sc_hd__fill_2
X_2490_ _0946_ _0709_ _0802_ _0947_ vssd1 vssd1 vccd1 vccd1 _0948_ sky130_fd_sc_hd__a31o_1
XFILLER_0_50_363 vssd1 vssd1 vccd1 vccd1 sky130_fd_sc_hd__fill_1
XFILLER_0_4_15 vssd1 vssd1 vccd1 vccd1 sky130_fd_sc_hd__decap_8
X_4160_ net307 vssd1 vssd1 vccd1 vccd1 _2080_ sky130_fd_sc_hd__clkbuf_1
X_3111_ u_timer.count_reg\[22\] _1541_ vssd1 vssd1 vccd1 vccd1 _1542_ sky130_fd_sc_hd__nor2_1
X_4091_ _2041_ vssd1 vssd1 vccd1 vccd1 _0508_ sky130_fd_sc_hd__clkbuf_1
X_3042_ u_timer.count_reg\[1\] u_timer.count_reg\[0\] u_timer.count_reg\[2\] vssd1
+ vssd1 vccd1 vccd1 _1493_ sky130_fd_sc_hd__a21oi_1
XFILLER_0_81_55 vssd1 vssd1 vccd1 vccd1 sky130_fd_sc_hd__fill_1
XFILLER_0_81_99 vssd1 vssd1 vccd1 vccd1 sky130_fd_sc_hd__fill_1
X_3944_ net240 vssd1 vssd1 vccd1 vccd1 _1968_ sky130_fd_sc_hd__clkbuf_1
XFILLER_0_85_293 vccd1 vssd1 vccd1 vssd1 sky130_ef_sc_hd__decap_12
X_3875_ _1933_ vssd1 vssd1 vccd1 vccd1 _0400_ sky130_fd_sc_hd__clkbuf_1
XFILLER_0_45_124 vccd1 vssd1 vccd1 vssd1 sky130_ef_sc_hd__decap_12
X_2826_ _1252_ _1254_ _1251_ _0736_ vssd1 vssd1 vccd1 vccd1 _1284_ sky130_fd_sc_hd__and4_1
XFILLER_0_60_138 vssd1 vssd1 vccd1 vccd1 sky130_fd_sc_hd__fill_2
X_2757_ u_core.u_regfile.rf\[6\]\[20\] vssd1 vssd1 vccd1 vccd1 _1215_ sky130_fd_sc_hd__inv_2
XFILLER_0_76_3 vccd1 vssd1 vccd1 vssd1 sky130_ef_sc_hd__decap_12
X_2688_ u_core.u_regfile.rf\[31\]\[25\] _0895_ _0745_ _0715_ vssd1 vssd1 vccd1 vccd1
+ _1146_ sky130_fd_sc_hd__o22a_2
X_4427_ clknet_leaf_9_clk _0238_ vssd1 vssd1 vccd1 vccd1 u_core.u_regfile.rf\[29\]\[31\]
+ sky130_fd_sc_hd__dfxtp_1
XTAP_260 vssd1 vccd1 sky130_fd_sc_hd__tapvpwrvgnd_1
X_4358_ clknet_leaf_18_clk _0169_ vssd1 vssd1 vccd1 vccd1 u_core.u_regfile.rf\[5\]\[26\]
+ sky130_fd_sc_hd__dfxtp_1
XTAP_293 vssd1 vccd1 sky130_fd_sc_hd__tapvpwrvgnd_1
X_3309_ _1645_ vssd1 vssd1 vccd1 vccd1 _0122_ sky130_fd_sc_hd__clkbuf_1
XTAP_282 vssd1 vccd1 sky130_fd_sc_hd__tapvpwrvgnd_1
XTAP_271 vssd1 vccd1 sky130_fd_sc_hd__tapvpwrvgnd_1
X_4289_ clknet_leaf_1_clk _0100_ vssd1 vssd1 vccd1 vccd1 u_core.u_regfile.rf\[6\]\[21\]
+ sky130_fd_sc_hd__dfxtp_1
Xfanout31 net32 vssd1 vssd1 vccd1 vccd1 net31 sky130_fd_sc_hd__clkbuf_2
XFILLER_0_64_477 vccd1 vssd1 vccd1 vssd1 sky130_ef_sc_hd__decap_12
XFILLER_0_10_29 vccd1 vssd1 vccd1 vssd1 sky130_ef_sc_hd__decap_12
XFILLER_0_19_27 vssd1 vssd1 vccd1 vccd1 sky130_fd_sc_hd__decap_8
XFILLER_0_27_102 vssd1 vssd1 vccd1 vccd1 sky130_fd_sc_hd__fill_2
XFILLER_0_27_113 vssd1 vssd1 vccd1 vccd1 sky130_fd_sc_hd__fill_1
X_3660_ _1822_ vssd1 vssd1 vccd1 vccd1 _0296_ sky130_fd_sc_hd__clkbuf_1
X_3591_ _1791_ _1792_ _1793_ net78 vssd1 vssd1 vccd1 vccd1 _0256_ sky130_fd_sc_hd__o31a_1
X_2611_ _1051_ _1057_ _1063_ vssd1 vssd1 vccd1 vccd1 _1069_ sky130_fd_sc_hd__nor3_1
XFILLER_0_70_458 vccd1 vssd1 vccd1 vssd1 sky130_ef_sc_hd__decap_12
X_2542_ _0980_ _0984_ _0998_ _0999_ vssd1 vssd1 vccd1 vccd1 _1000_ sky130_fd_sc_hd__a31oi_4
X_4212_ net232 vssd1 vssd1 vccd1 vccd1 _2106_ sky130_fd_sc_hd__clkbuf_1
X_2473_ _0900_ _0929_ _0930_ vssd1 vssd1 vccd1 vccd1 _0931_ sky130_fd_sc_hd__o21ai_1
XFILLER_0_76_77 vssd1 vssd1 vccd1 vccd1 sky130_fd_sc_hd__decap_6
X_4143_ net507 _2062_ _2070_ _2061_ vssd1 vssd1 vccd1 vccd1 _0531_ sky130_fd_sc_hd__o2bb2ai_1
X_4074_ net148 vssd1 vssd1 vccd1 vccd1 _2033_ sky130_fd_sc_hd__clkbuf_1
X_3025_ _1405_ vssd1 vssd1 vccd1 vccd1 _1482_ sky130_fd_sc_hd__clkbuf_4
X_3927_ _1959_ vssd1 vssd1 vccd1 vccd1 _0426_ sky130_fd_sc_hd__clkbuf_1
X_3858_ net316 vssd1 vssd1 vccd1 vccd1 _1925_ sky130_fd_sc_hd__clkbuf_1
XFILLER_0_46_488 vccd1 vssd1 vccd1 vssd1 sky130_ef_sc_hd__decap_12
X_2809_ _0879_ _1265_ _1266_ vssd1 vssd1 vccd1 vccd1 _1267_ sky130_fd_sc_hd__a21oi_2
X_3789_ _1344_ _1381_ _1875_ _1890_ vssd1 vssd1 vccd1 vccd1 _0357_ sky130_fd_sc_hd__a31o_1
XFILLER_0_41_160 vssd1 vssd1 vccd1 vccd1 sky130_fd_sc_hd__decap_8
XFILLER_0_14_385 vssd1 vssd1 vccd1 vccd1 sky130_fd_sc_hd__fill_2
XFILLER_0_49_271 vssd1 vssd1 vccd1 vccd1 sky130_fd_sc_hd__fill_1
XFILLER_0_64_230 vssd1 vssd1 vccd1 vccd1 sky130_fd_sc_hd__fill_1
XFILLER_0_52_414 vssd1 vssd1 vccd1 vccd1 sky130_fd_sc_hd__decap_6
XFILLER_0_32_160 vssd1 vssd1 vccd1 vccd1 sky130_fd_sc_hd__fill_2
XFILLER_0_1_27 vccd1 vssd1 vccd1 vssd1 sky130_ef_sc_hd__decap_12
XFILLER_0_62_79 vssd1 vssd1 vccd1 vccd1 sky130_fd_sc_hd__fill_1
XFILLER_0_7_305 vssd1 vssd1 vccd1 vccd1 sky130_fd_sc_hd__decap_4
X_4761_ clknet_leaf_14_clk _0026_ net29 vssd1 vssd1 vccd1 vccd1 u_timer.count_reg\[27\]
+ sky130_fd_sc_hd__dfrtp_4
XFILLER_0_28_455 vssd1 vssd1 vccd1 vccd1 sky130_fd_sc_hd__fill_2
X_4692_ clknet_leaf_26_clk _0493_ vssd1 vssd1 vccd1 vccd1 u_core.u_regfile.rf\[24\]\[30\]
+ sky130_fd_sc_hd__dfxtp_1
X_3712_ _1848_ vssd1 vssd1 vccd1 vccd1 _0322_ sky130_fd_sc_hd__clkbuf_1
X_3643_ net302 vssd1 vssd1 vccd1 vccd1 _1814_ sky130_fd_sc_hd__clkbuf_1
XFILLER_0_43_447 vssd1 vssd1 vccd1 vccd1 sky130_fd_sc_hd__fill_1
X_3574_ _1632_ _1633_ _1790_ net86 vssd1 vssd1 vccd1 vccd1 _0242_ sky130_fd_sc_hd__o31a_1
X_2525_ _0879_ u_core.u_regfile.rf\[5\]\[10\] _0724_ _0977_ vssd1 vssd1 vccd1 vccd1
+ _0983_ sky130_fd_sc_hd__o211ai_2
X_2456_ _0867_ vssd1 vssd1 vccd1 vccd1 _0914_ sky130_fd_sc_hd__buf_4
Xhold29 u_core.u_regfile.rf\[5\]\[4\] vssd1 vssd1 vccd1 vccd1 net62 sky130_fd_sc_hd__dlygate4sd3_1
Xhold18 u_core.u_regfile.rf\[5\]\[22\] vssd1 vssd1 vccd1 vccd1 net51 sky130_fd_sc_hd__dlygate4sd3_1
X_4126_ net183 vssd1 vssd1 vccd1 vccd1 _2059_ sky130_fd_sc_hd__clkbuf_1
XFILLER_0_39_3 vccd1 vssd1 vccd1 vssd1 sky130_ef_sc_hd__decap_12
X_2387_ _0839_ _0844_ _0736_ vssd1 vssd1 vccd1 vccd1 _0845_ sky130_fd_sc_hd__and3b_1
X_4057_ _2024_ vssd1 vssd1 vccd1 vccd1 _0491_ sky130_fd_sc_hd__clkbuf_1
XFILLER_0_78_322 vssd1 vssd1 vccd1 vccd1 sky130_fd_sc_hd__decap_3
X_3008_ _1464_ _1465_ vssd1 vssd1 vccd1 vccd1 _1466_ sky130_fd_sc_hd__nand2_1
XFILLER_0_81_509 vssd1 vssd1 vccd1 vccd1 sky130_fd_sc_hd__fill_1
XFILLER_0_6_371 vssd1 vssd1 vccd1 vccd1 sky130_fd_sc_hd__fill_1
XFILLER_0_34_447 vssd1 vssd1 vccd1 vccd1 sky130_fd_sc_hd__fill_1
XFILLER_0_42_491 vssd1 vssd1 vccd1 vccd1 sky130_fd_sc_hd__fill_1
XFILLER_0_29_219 vssd1 vssd1 vccd1 vccd1 sky130_fd_sc_hd__decap_4
XFILLER_0_25_447 vssd1 vssd1 vccd1 vccd1 sky130_fd_sc_hd__fill_1
XTAP_826 vssd1 vccd1 sky130_fd_sc_hd__tapvpwrvgnd_1
X_3290_ net491 vssd1 vssd1 vccd1 vccd1 _1636_ sky130_fd_sc_hd__clkbuf_1
X_2310_ u_core.u_regfile.rf\[5\]\[29\] _0694_ _0719_ _0724_ _0767_ vssd1 vssd1 vccd1
+ vccd1 _0768_ sky130_fd_sc_hd__o2111a_2
XTAP_804 vssd1 vccd1 sky130_fd_sc_hd__tapvpwrvgnd_1
XTAP_815 vssd1 vccd1 sky130_fd_sc_hd__tapvpwrvgnd_1
XTAP_859 vssd1 vccd1 sky130_fd_sc_hd__tapvpwrvgnd_1
XTAP_848 vssd1 vccd1 sky130_fd_sc_hd__tapvpwrvgnd_1
XTAP_837 vssd1 vccd1 sky130_fd_sc_hd__tapvpwrvgnd_1
X_2241_ _0687_ _0695_ vssd1 vssd1 vccd1 vccd1 _0699_ sky130_fd_sc_hd__nand2_1
X_2172_ u_timer.count_reg\[12\] _0625_ vssd1 vssd1 vccd1 vccd1 _0631_ sky130_fd_sc_hd__or2_1
XFILLER_0_63_509 vssd1 vssd1 vccd1 vccd1 sky130_fd_sc_hd__fill_1
X_4744_ clknet_leaf_21_clk _0008_ net28 vssd1 vssd1 vccd1 vccd1 u_timer.count_reg\[10\]
+ sky130_fd_sc_hd__dfrtp_4
XFILLER_0_7_124 vssd1 vssd1 vccd1 vccd1 sky130_fd_sc_hd__decap_4
XFILLER_0_83_391 vssd1 vssd1 vccd1 vccd1 sky130_fd_sc_hd__fill_1
XFILLER_0_22_82 vssd1 vssd1 vccd1 vccd1 sky130_fd_sc_hd__fill_2
X_4675_ clknet_leaf_38_clk _0476_ vssd1 vssd1 vccd1 vccd1 u_core.u_regfile.rf\[24\]\[13\]
+ sky130_fd_sc_hd__dfxtp_1
XFILLER_0_31_439 vssd1 vssd1 vccd1 vccd1 sky130_fd_sc_hd__fill_1
X_3626_ _1805_ vssd1 vssd1 vccd1 vccd1 _0279_ sky130_fd_sc_hd__clkbuf_1
XFILLER_0_3_385 vssd1 vssd1 vccd1 vccd1 sky130_fd_sc_hd__decap_6
X_3557_ _1783_ vssd1 vssd1 vccd1 vccd1 _0232_ sky130_fd_sc_hd__clkbuf_1
X_2508_ _0957_ _0963_ _0964_ _0965_ vssd1 vssd1 vccd1 vccd1 _0966_ sky130_fd_sc_hd__nand4b_4
X_3488_ _1731_ _1413_ _1739_ _1480_ _1747_ vssd1 vssd1 vccd1 vccd1 _1748_ sky130_fd_sc_hd__a41o_1
X_2439_ _0687_ u_imem.addr\[4\] vssd1 vssd1 vccd1 vccd1 _0897_ sky130_fd_sc_hd__or2_1
X_4109_ _2050_ vssd1 vssd1 vccd1 vccd1 _0517_ sky130_fd_sc_hd__clkbuf_1
XFILLER_0_2_70 vccd1 vssd1 vccd1 vssd1 sky130_ef_sc_hd__decap_12
XPHY_103 vssd1 vssd1 vccd1 vccd1 sky130_fd_sc_hd__decap_3
XPHY_114 vssd1 vssd1 vccd1 vccd1 sky130_fd_sc_hd__decap_3
XPHY_125 vssd1 vssd1 vccd1 vccd1 sky130_fd_sc_hd__decap_3
XFILLER_0_66_325 vssd1 vssd1 vccd1 vccd1 sky130_fd_sc_hd__fill_1
XPHY_158 vssd1 vssd1 vccd1 vccd1 sky130_fd_sc_hd__decap_3
XPHY_147 vssd1 vssd1 vccd1 vccd1 sky130_fd_sc_hd__decap_3
XFILLER_0_54_509 vssd1 vssd1 vccd1 vccd1 sky130_fd_sc_hd__fill_1
XPHY_136 vssd1 vssd1 vccd1 vccd1 sky130_fd_sc_hd__decap_3
XPHY_169 vssd1 vssd1 vccd1 vccd1 sky130_fd_sc_hd__decap_3
XFILLER_0_74_380 vssd1 vssd1 vccd1 vccd1 sky130_fd_sc_hd__fill_2
XFILLER_0_34_277 vssd1 vssd1 vccd1 vccd1 sky130_fd_sc_hd__fill_2
XFILLER_0_6_190 vssd1 vssd1 vccd1 vccd1 sky130_fd_sc_hd__decap_6
XFILLER_0_43_15 vccd1 vssd1 vccd1 vssd1 sky130_ef_sc_hd__decap_12
XFILLER_0_69_152 vssd1 vssd1 vccd1 vccd1 sky130_fd_sc_hd__fill_1
XPHY_5 vssd1 vssd1 vccd1 vccd1 sky130_fd_sc_hd__decap_3
XFILLER_0_45_509 vssd1 vssd1 vccd1 vccd1 sky130_fd_sc_hd__fill_1
XFILLER_0_25_222 vssd1 vssd1 vccd1 vccd1 sky130_fd_sc_hd__fill_2
X_2790_ _0758_ _0741_ u_core.u_regfile.rf\[28\]\[23\] vssd1 vssd1 vccd1 vccd1 _1248_
+ sky130_fd_sc_hd__o21a_1
XFILLER_0_7_15 vccd1 vssd1 vccd1 vssd1 sky130_ef_sc_hd__decap_12
X_4460_ clknet_leaf_1_clk _0261_ vssd1 vssd1 vccd1 vccd1 u_core.u_regfile.rf\[7\]\[22\]
+ sky130_fd_sc_hd__dfxtp_1
XFILLER_0_25_288 vssd1 vssd1 vccd1 vccd1 sky130_fd_sc_hd__decap_8
Xhold307 u_core.u_regfile.rf\[2\]\[25\] vssd1 vssd1 vccd1 vccd1 net340 sky130_fd_sc_hd__dlygate4sd3_1
X_4391_ clknet_leaf_15_clk _0202_ net28 vssd1 vssd1 vccd1 vccd1 u_timer.threshold_reg\[27\]
+ sky130_fd_sc_hd__dfrtp_1
Xhold318 u_core.u_regfile.rf\[25\]\[12\] vssd1 vssd1 vccd1 vccd1 net351 sky130_fd_sc_hd__dlygate4sd3_1
Xhold329 u_core.u_regfile.rf\[3\]\[11\] vssd1 vssd1 vccd1 vccd1 net362 sky130_fd_sc_hd__dlygate4sd3_1
X_3411_ _1009_ _1014_ _1678_ _1683_ _1686_ vssd1 vssd1 vccd1 vccd1 _1692_ sky130_fd_sc_hd__o2111a_1
XFILLER_0_0_333 vssd1 vssd1 vccd1 vccd1 sky130_fd_sc_hd__decap_3
X_3342_ net457 vssd1 vssd1 vccd1 vccd1 _1662_ sky130_fd_sc_hd__clkbuf_1
XTAP_601 vssd1 vccd1 sky130_fd_sc_hd__tapvpwrvgnd_1
XTAP_612 vssd1 vccd1 sky130_fd_sc_hd__tapvpwrvgnd_1
XTAP_623 vssd1 vccd1 sky130_fd_sc_hd__tapvpwrvgnd_1
XTAP_634 vssd1 vccd1 sky130_fd_sc_hd__tapvpwrvgnd_1
X_3273_ _1629_ _1630_ _1631_ net92 vssd1 vssd1 vccd1 vccd1 _0100_ sky130_fd_sc_hd__o31a_1
XTAP_645 vssd1 vccd1 sky130_fd_sc_hd__tapvpwrvgnd_1
XTAP_656 vssd1 vccd1 sky130_fd_sc_hd__tapvpwrvgnd_1
XTAP_667 vssd1 vccd1 sky130_fd_sc_hd__tapvpwrvgnd_1
X_2224_ _0672_ _0679_ _0682_ vssd1 vssd1 vccd1 vccd1 _0683_ sky130_fd_sc_hd__o21bai_1
XTAP_678 vssd1 vccd1 sky130_fd_sc_hd__tapvpwrvgnd_1
XTAP_689 vssd1 vccd1 sky130_fd_sc_hd__tapvpwrvgnd_1
XFILLER_0_84_77 vssd1 vssd1 vccd1 vccd1 sky130_fd_sc_hd__decap_6
X_2155_ u_timer.count_reg\[15\] vssd1 vssd1 vccd1 vccd1 _0614_ sky130_fd_sc_hd__inv_2
XFILLER_0_75_111 vssd1 vssd1 vccd1 vccd1 sky130_fd_sc_hd__fill_1
XFILLER_0_75_144 vccd1 vssd1 vccd1 vssd1 sky130_ef_sc_hd__decap_12
XFILLER_0_75_177 vssd1 vssd1 vccd1 vccd1 sky130_fd_sc_hd__decap_8
XFILLER_0_8_488 vssd1 vssd1 vccd1 vccd1 sky130_fd_sc_hd__decap_4
X_2988_ _1445_ _0894_ vssd1 vssd1 vccd1 vccd1 _1446_ sky130_fd_sc_hd__nand2_1
X_4727_ clknet_leaf_13_clk _0528_ net23 vssd1 vssd1 vccd1 vccd1 net4 sky130_fd_sc_hd__dfrtp_2
XFILLER_0_71_383 vssd1 vssd1 vccd1 vccd1 sky130_fd_sc_hd__fill_1
XFILLER_0_16_277 vssd1 vssd1 vccd1 vccd1 sky130_fd_sc_hd__decap_4
X_4658_ clknet_leaf_25_clk _0459_ vssd1 vssd1 vccd1 vccd1 u_core.u_regfile.rf\[26\]\[28\]
+ sky130_fd_sc_hd__dfxtp_1
X_3609_ net177 vssd1 vssd1 vccd1 vccd1 _1797_ sky130_fd_sc_hd__clkbuf_1
X_4589_ clknet_leaf_36_clk _0390_ vssd1 vssd1 vccd1 vccd1 u_core.u_regfile.rf\[27\]\[23\]
+ sky130_fd_sc_hd__dfxtp_1
XFILLER_0_79_461 vssd1 vssd1 vccd1 vccd1 sky130_fd_sc_hd__fill_1
XFILLER_0_66_188 vssd1 vssd1 vccd1 vccd1 sky130_fd_sc_hd__decap_8
XFILLER_0_81_169 vssd1 vssd1 vccd1 vccd1 sky130_fd_sc_hd__decap_4
XFILLER_0_38_15 vccd1 vssd1 vccd1 vssd1 sky130_ef_sc_hd__decap_12
XFILLER_0_38_37 vssd1 vssd1 vccd1 vccd1 sky130_fd_sc_hd__decap_3
X_3960_ net166 vssd1 vssd1 vccd1 vccd1 _1976_ sky130_fd_sc_hd__clkbuf_1
X_2911_ _1223_ _1368_ _1276_ _1275_ vssd1 vssd1 vccd1 vccd1 _1369_ sky130_fd_sc_hd__o211a_1
X_3891_ _1941_ vssd1 vssd1 vccd1 vccd1 _0408_ sky130_fd_sc_hd__clkbuf_1
X_2842_ _1274_ _1293_ _1299_ vssd1 vssd1 vccd1 vccd1 _1300_ sky130_fd_sc_hd__a21oi_2
XFILLER_0_5_425 vssd1 vssd1 vccd1 vccd1 sky130_fd_sc_hd__fill_1
X_2773_ _0813_ _1228_ _1229_ _1230_ vssd1 vssd1 vccd1 vccd1 _1231_ sky130_fd_sc_hd__a31o_1
XFILLER_0_13_225 vssd1 vssd1 vccd1 vccd1 sky130_fd_sc_hd__decap_6
XFILLER_0_53_372 vssd1 vssd1 vccd1 vccd1 sky130_fd_sc_hd__fill_1
X_4512_ clknet_leaf_22_clk _0313_ vssd1 vssd1 vccd1 vccd1 u_core.u_regfile.rf\[2\]\[10\]
+ sky130_fd_sc_hd__dfxtp_1
XFILLER_0_79_55 vssd1 vssd1 vccd1 vccd1 sky130_fd_sc_hd__fill_1
Xhold115 u_core.u_regfile.rf\[25\]\[5\] vssd1 vssd1 vccd1 vccd1 net148 sky130_fd_sc_hd__dlygate4sd3_1
Xhold126 u_core.u_regfile.rf\[24\]\[20\] vssd1 vssd1 vccd1 vccd1 net159 sky130_fd_sc_hd__dlygate4sd3_1
Xhold104 u_core.u_regfile.rf\[3\]\[19\] vssd1 vssd1 vccd1 vccd1 net137 sky130_fd_sc_hd__dlygate4sd3_1
X_4443_ clknet_leaf_0_clk _0244_ vssd1 vssd1 vccd1 vccd1 u_core.u_regfile.rf\[7\]\[5\]
+ sky130_fd_sc_hd__dfxtp_1
Xhold159 u_core.u_regfile.rf\[27\]\[18\] vssd1 vssd1 vccd1 vccd1 net192 sky130_fd_sc_hd__dlygate4sd3_1
Xhold137 u_core.u_regfile.rf\[2\]\[7\] vssd1 vssd1 vccd1 vccd1 net170 sky130_fd_sc_hd__dlygate4sd3_1
Xhold148 u_core.u_regfile.rf\[3\]\[13\] vssd1 vssd1 vccd1 vccd1 net181 sky130_fd_sc_hd__dlygate4sd3_1
XFILLER_0_0_141 vccd1 vssd1 vccd1 vssd1 sky130_ef_sc_hd__decap_12
X_4374_ clknet_leaf_20_clk _0185_ net27 vssd1 vssd1 vccd1 vccd1 u_timer.threshold_reg\[10\]
+ sky130_fd_sc_hd__dfstp_1
X_3325_ _1653_ vssd1 vssd1 vccd1 vccd1 _0130_ sky130_fd_sc_hd__clkbuf_1
XTAP_420 vssd1 vccd1 sky130_fd_sc_hd__tapvpwrvgnd_1
XTAP_431 vssd1 vccd1 sky130_fd_sc_hd__tapvpwrvgnd_1
XTAP_442 vssd1 vccd1 sky130_fd_sc_hd__tapvpwrvgnd_1
X_3256_ _1487_ vssd1 vssd1 vccd1 vccd1 _1626_ sky130_fd_sc_hd__buf_2
XTAP_453 vssd1 vccd1 sky130_fd_sc_hd__tapvpwrvgnd_1
XTAP_464 vssd1 vccd1 sky130_fd_sc_hd__tapvpwrvgnd_1
XTAP_475 vssd1 vccd1 sky130_fd_sc_hd__tapvpwrvgnd_1
X_2207_ u_timer.threshold_reg\[20\] vssd1 vssd1 vccd1 vccd1 _0666_ sky130_fd_sc_hd__inv_2
XTAP_486 vssd1 vccd1 sky130_fd_sc_hd__tapvpwrvgnd_1
XTAP_497 vssd1 vccd1 sky130_fd_sc_hd__tapvpwrvgnd_1
XFILLER_0_21_3 vccd1 vssd1 vccd1 vssd1 sky130_ef_sc_hd__decap_12
X_3187_ net447 vssd1 vssd1 vccd1 vccd1 _1595_ sky130_fd_sc_hd__clkbuf_1
X_2138_ u_timer.count_reg\[28\] vssd1 vssd1 vccd1 vccd1 _0597_ sky130_fd_sc_hd__inv_2
XFILLER_0_48_155 vssd1 vssd1 vccd1 vccd1 sky130_fd_sc_hd__decap_3
XFILLER_0_63_103 vssd1 vssd1 vccd1 vccd1 sky130_fd_sc_hd__fill_1
XFILLER_0_29_391 vssd1 vssd1 vccd1 vccd1 sky130_fd_sc_hd__fill_1
XFILLER_0_36_328 vssd1 vssd1 vccd1 vccd1 sky130_fd_sc_hd__decap_8
XFILLER_0_63_169 vssd1 vssd1 vccd1 vccd1 sky130_fd_sc_hd__decap_3
XFILLER_0_8_91 vssd1 vssd1 vccd1 vccd1 sky130_fd_sc_hd__fill_1
XFILLER_0_24_39 vssd1 vssd1 vccd1 vccd1 sky130_fd_sc_hd__decap_4
XFILLER_0_82_401 vccd1 vssd1 vccd1 vssd1 sky130_ef_sc_hd__decap_12
XFILLER_0_67_486 vccd1 vssd1 vccd1 vssd1 sky130_ef_sc_hd__decap_12
XFILLER_0_82_445 vccd1 vssd1 vccd1 vssd1 sky130_ef_sc_hd__decap_12
XFILLER_0_54_114 vssd1 vssd1 vccd1 vccd1 sky130_fd_sc_hd__decap_4
XFILLER_0_82_489 vccd1 vssd1 vccd1 vssd1 sky130_ef_sc_hd__decap_12
X_3110_ _0664_ _1538_ _1541_ _0001_ vssd1 vssd1 vccd1 vccd1 _0020_ sky130_fd_sc_hd__a211oi_1
X_4090_ net367 vssd1 vssd1 vccd1 vccd1 _2041_ sky130_fd_sc_hd__clkbuf_1
XFILLER_0_65_57 vccd1 vssd1 vccd1 vssd1 sky130_ef_sc_hd__decap_12
X_3041_ u_timer.count_reg\[2\] u_timer.count_reg\[1\] u_timer.count_reg\[0\] vssd1
+ vssd1 vccd1 vccd1 _1492_ sky130_fd_sc_hd__and3_1
XFILLER_0_77_228 vssd1 vssd1 vccd1 vccd1 sky130_fd_sc_hd__decap_8
X_3943_ _1967_ vssd1 vssd1 vccd1 vccd1 _0434_ sky130_fd_sc_hd__clkbuf_1
XFILLER_0_73_445 vssd1 vssd1 vccd1 vccd1 sky130_fd_sc_hd__decap_3
X_3874_ net401 vssd1 vssd1 vccd1 vccd1 _1933_ sky130_fd_sc_hd__clkbuf_1
XFILLER_0_45_136 vssd1 vssd1 vccd1 vccd1 sky130_fd_sc_hd__fill_2
XFILLER_0_45_147 vssd1 vssd1 vccd1 vccd1 sky130_fd_sc_hd__fill_1
XFILLER_0_45_169 vccd1 vssd1 vccd1 vssd1 sky130_ef_sc_hd__decap_12
X_2825_ _1268_ _1282_ vssd1 vssd1 vccd1 vccd1 _1283_ sky130_fd_sc_hd__nor2_1
XFILLER_0_26_361 vssd1 vssd1 vccd1 vccd1 sky130_fd_sc_hd__decap_3
X_2756_ _0900_ _1212_ _1213_ vssd1 vssd1 vccd1 vccd1 _1214_ sky130_fd_sc_hd__o21a_1
X_2687_ _1143_ _1144_ vssd1 vssd1 vccd1 vccd1 _1145_ sky130_fd_sc_hd__nand2_1
XFILLER_0_1_461 vccd1 vssd1 vccd1 vssd1 sky130_ef_sc_hd__decap_12
X_4426_ clknet_leaf_9_clk _0237_ vssd1 vssd1 vccd1 vccd1 u_core.u_regfile.rf\[29\]\[30\]
+ sky130_fd_sc_hd__dfxtp_1
XFILLER_0_69_3 vccd1 vssd1 vccd1 vssd1 sky130_ef_sc_hd__decap_12
XTAP_250 vssd1 vccd1 sky130_fd_sc_hd__tapvpwrvgnd_1
XFILLER_0_39_91 vssd1 vssd1 vccd1 vccd1 sky130_fd_sc_hd__fill_2
X_4357_ clknet_leaf_18_clk _0168_ vssd1 vssd1 vccd1 vccd1 u_core.u_regfile.rf\[5\]\[25\]
+ sky130_fd_sc_hd__dfxtp_1
X_3308_ net542 vssd1 vssd1 vccd1 vccd1 _1645_ sky130_fd_sc_hd__clkbuf_1
XTAP_283 vssd1 vccd1 sky130_fd_sc_hd__tapvpwrvgnd_1
XTAP_272 vssd1 vccd1 sky130_fd_sc_hd__tapvpwrvgnd_1
XTAP_261 vssd1 vccd1 sky130_fd_sc_hd__tapvpwrvgnd_1
X_4288_ clknet_leaf_1_clk _0099_ vssd1 vssd1 vccd1 vccd1 u_core.u_regfile.rf\[6\]\[20\]
+ sky130_fd_sc_hd__dfxtp_1
XTAP_294 vssd1 vccd1 sky130_fd_sc_hd__tapvpwrvgnd_1
X_3239_ net554 vssd1 vssd1 vccd1 vccd1 _1621_ sky130_fd_sc_hd__clkbuf_1
XFILLER_0_55_90 vssd1 vssd1 vccd1 vccd1 sky130_fd_sc_hd__fill_1
Xfanout21 net22 vssd1 vssd1 vccd1 vccd1 net21 sky130_fd_sc_hd__clkbuf_4
Xfanout32 net33 vssd1 vssd1 vccd1 vccd1 net32 sky130_fd_sc_hd__clkbuf_2
XFILLER_0_36_147 vssd1 vssd1 vccd1 vccd1 sky130_fd_sc_hd__decap_4
XFILLER_0_64_489 vccd1 vssd1 vccd1 vssd1 sky130_ef_sc_hd__decap_12
Xhold490 u_core.u_regfile.rf\[31\]\[12\] vssd1 vssd1 vccd1 vccd1 net523 sky130_fd_sc_hd__dlygate4sd3_1
XFILLER_0_51_15 vccd1 vssd1 vccd1 vssd1 sky130_ef_sc_hd__decap_12
XFILLER_0_55_401 vssd1 vssd1 vccd1 vccd1 sky130_fd_sc_hd__decap_3
XFILLER_0_7_509 vssd1 vssd1 vccd1 vccd1 sky130_fd_sc_hd__fill_1
XFILLER_0_82_253 vssd1 vssd1 vccd1 vccd1 sky130_fd_sc_hd__fill_1
XFILLER_0_55_445 vssd1 vssd1 vccd1 vccd1 sky130_fd_sc_hd__decap_3
X_3590_ _1791_ _1792_ _1793_ net45 vssd1 vssd1 vccd1 vccd1 _0255_ sky130_fd_sc_hd__o31a_1
X_2610_ _1051_ _1057_ _1063_ _1067_ vssd1 vssd1 vccd1 vccd1 _1068_ sky130_fd_sc_hd__o31a_1
XFILLER_0_2_247 vssd1 vssd1 vccd1 vccd1 sky130_fd_sc_hd__decap_4
X_2541_ _0996_ _0987_ _0965_ _0988_ vssd1 vssd1 vccd1 vccd1 _0999_ sky130_fd_sc_hd__and4_2
X_2472_ u_core.u_regfile.rf\[5\]\[15\] _0733_ _0904_ _0770_ _0773_ vssd1 vssd1 vccd1
+ vccd1 _0930_ sky130_fd_sc_hd__o32a_1
X_4211_ _2105_ vssd1 vssd1 vccd1 vccd1 _0564_ sky130_fd_sc_hd__clkbuf_1
X_4142_ _1737_ _1715_ _1706_ _1094_ vssd1 vssd1 vccd1 vccd1 _2070_ sky130_fd_sc_hd__nand4_1
X_4073_ _2032_ vssd1 vssd1 vccd1 vccd1 _0499_ sky130_fd_sc_hd__clkbuf_1
X_3024_ _1481_ vssd1 vssd1 vccd1 vccd1 _0002_ sky130_fd_sc_hd__inv_2
XFILLER_0_25_82 vssd1 vssd1 vccd1 vccd1 sky130_fd_sc_hd__fill_1
X_3926_ net384 vssd1 vssd1 vccd1 vccd1 _1959_ sky130_fd_sc_hd__clkbuf_1
XFILLER_0_18_136 vssd1 vssd1 vccd1 vccd1 sky130_fd_sc_hd__fill_1
X_3857_ _1924_ vssd1 vssd1 vccd1 vccd1 _0391_ sky130_fd_sc_hd__clkbuf_1
XFILLER_0_14_331 vssd1 vssd1 vccd1 vccd1 sky130_fd_sc_hd__decap_6
X_2808_ u_core.u_regfile.rf\[5\]\[22\] _0693_ _0723_ vssd1 vssd1 vccd1 vccd1 _1266_
+ sky130_fd_sc_hd__o21ai_1
X_3788_ _1484_ _1877_ net494 vssd1 vssd1 vccd1 vccd1 _1890_ sky130_fd_sc_hd__o21a_1
X_2739_ _0866_ u_core.u_regfile.rf\[1\]\[17\] _0857_ _0867_ vssd1 vssd1 vccd1 vccd1
+ _1197_ sky130_fd_sc_hd__a31o_1
X_4409_ clknet_leaf_32_clk _0220_ vssd1 vssd1 vccd1 vccd1 u_core.u_regfile.rf\[29\]\[13\]
+ sky130_fd_sc_hd__dfxtp_1
XFILLER_0_64_253 vccd1 vssd1 vccd1 vssd1 sky130_ef_sc_hd__decap_12
XFILLER_0_37_489 vssd1 vssd1 vccd1 vccd1 sky130_fd_sc_hd__decap_6
XFILLER_0_52_459 vssd1 vssd1 vccd1 vccd1 sky130_fd_sc_hd__fill_1
XFILLER_0_20_334 vssd1 vssd1 vccd1 vccd1 sky130_fd_sc_hd__fill_2
XFILLER_0_46_15 vccd1 vssd1 vccd1 vssd1 sky130_ef_sc_hd__decap_12
XFILLER_0_1_39 vccd1 vssd1 vccd1 vssd1 sky130_ef_sc_hd__decap_12
X_4760_ clknet_leaf_14_clk _0025_ net29 vssd1 vssd1 vccd1 vccd1 u_timer.count_reg\[26\]
+ sky130_fd_sc_hd__dfrtp_4
X_4691_ clknet_leaf_24_clk _0492_ vssd1 vssd1 vccd1 vccd1 u_core.u_regfile.rf\[24\]\[29\]
+ sky130_fd_sc_hd__dfxtp_1
X_3711_ net347 vssd1 vssd1 vccd1 vccd1 _1848_ sky130_fd_sc_hd__clkbuf_1
X_3642_ _1813_ vssd1 vssd1 vccd1 vccd1 _0287_ sky130_fd_sc_hd__clkbuf_1
XFILLER_0_55_297 vssd1 vssd1 vccd1 vccd1 sky130_fd_sc_hd__decap_4
XFILLER_0_70_223 vssd1 vssd1 vccd1 vccd1 sky130_fd_sc_hd__fill_1
XFILLER_0_70_267 vssd1 vssd1 vccd1 vccd1 sky130_fd_sc_hd__decap_8
X_3573_ _1632_ _1633_ _1790_ net90 vssd1 vssd1 vccd1 vccd1 _0241_ sky130_fd_sc_hd__o31a_1
X_2524_ _0813_ _0970_ _0971_ _0972_ vssd1 vssd1 vccd1 vccd1 _0982_ sky130_fd_sc_hd__a31oi_4
X_2455_ _0866_ vssd1 vssd1 vccd1 vccd1 _0913_ sky130_fd_sc_hd__buf_4
Xhold19 u_core.u_regfile.rf\[7\]\[21\] vssd1 vssd1 vccd1 vccd1 net52 sky130_fd_sc_hd__dlygate4sd3_1
X_2386_ _0771_ _0774_ _0694_ u_core.u_regfile.rf\[5\]\[24\] _0843_ vssd1 vssd1 vccd1
+ vccd1 _0844_ sky130_fd_sc_hd__o221a_1
X_4125_ _2058_ vssd1 vssd1 vccd1 vccd1 _0525_ sky130_fd_sc_hd__clkbuf_1
X_4056_ net304 vssd1 vssd1 vccd1 vccd1 _2024_ sky130_fd_sc_hd__clkbuf_1
X_3007_ _0873_ _1005_ _1454_ vssd1 vssd1 vccd1 vccd1 _1465_ sky130_fd_sc_hd__nand3_2
XFILLER_0_19_401 vssd1 vssd1 vccd1 vccd1 sky130_fd_sc_hd__fill_1
XFILLER_0_46_231 vssd1 vssd1 vccd1 vccd1 sky130_fd_sc_hd__decap_6
X_3909_ _1950_ vssd1 vssd1 vccd1 vccd1 _0417_ sky130_fd_sc_hd__clkbuf_1
XFILLER_0_61_212 vssd1 vssd1 vccd1 vccd1 sky130_fd_sc_hd__fill_2
XFILLER_0_61_256 vssd1 vssd1 vccd1 vccd1 sky130_fd_sc_hd__fill_2
XFILLER_0_61_278 vssd1 vssd1 vccd1 vccd1 sky130_fd_sc_hd__fill_2
XFILLER_0_16_29 vssd1 vssd1 vccd1 vccd1 sky130_fd_sc_hd__decap_6
XFILLER_0_32_39 vssd1 vssd1 vccd1 vccd1 sky130_fd_sc_hd__decap_6
XFILLER_0_4_309 vccd1 vssd1 vccd1 vssd1 sky130_ef_sc_hd__decap_12
XFILLER_0_40_418 vssd1 vssd1 vccd1 vccd1 sky130_fd_sc_hd__fill_2
XFILLER_0_33_470 vssd1 vssd1 vccd1 vccd1 sky130_fd_sc_hd__decap_6
XTAP_805 vssd1 vccd1 sky130_fd_sc_hd__tapvpwrvgnd_1
XTAP_816 vssd1 vccd1 sky130_fd_sc_hd__tapvpwrvgnd_1
XTAP_849 vssd1 vccd1 sky130_fd_sc_hd__tapvpwrvgnd_1
XTAP_838 vssd1 vccd1 sky130_fd_sc_hd__tapvpwrvgnd_1
XTAP_827 vssd1 vccd1 sky130_fd_sc_hd__tapvpwrvgnd_1
X_2240_ _0697_ vssd1 vssd1 vccd1 vccd1 _0698_ sky130_fd_sc_hd__clkbuf_4
X_2171_ _0626_ _0629_ vssd1 vssd1 vccd1 vccd1 _0630_ sky130_fd_sc_hd__nor2_1
XFILLER_0_73_57 vccd1 vssd1 vccd1 vssd1 sky130_ef_sc_hd__decap_12
XFILLER_0_75_337 vssd1 vssd1 vccd1 vccd1 sky130_fd_sc_hd__fill_1
XFILLER_0_75_326 vssd1 vssd1 vccd1 vccd1 sky130_fd_sc_hd__fill_1
XFILLER_0_28_220 vssd1 vssd1 vccd1 vccd1 sky130_fd_sc_hd__decap_3
X_4743_ clknet_leaf_15_clk _0038_ net28 vssd1 vssd1 vccd1 vccd1 u_timer.count_reg\[9\]
+ sky130_fd_sc_hd__dfrtp_4
XFILLER_0_16_404 vssd1 vssd1 vccd1 vccd1 sky130_fd_sc_hd__fill_2
XFILLER_0_28_253 vssd1 vssd1 vccd1 vccd1 sky130_fd_sc_hd__decap_8
X_4674_ clknet_leaf_24_clk _0475_ vssd1 vssd1 vccd1 vccd1 u_core.u_regfile.rf\[24\]\[12\]
+ sky130_fd_sc_hd__dfxtp_1
X_3625_ net334 vssd1 vssd1 vccd1 vccd1 _1805_ sky130_fd_sc_hd__clkbuf_1
XFILLER_0_11_120 vssd1 vssd1 vccd1 vccd1 sky130_fd_sc_hd__decap_8
X_3556_ net402 vssd1 vssd1 vccd1 vccd1 _1783_ sky130_fd_sc_hd__clkbuf_1
X_2507_ _0734_ vssd1 vssd1 vccd1 vccd1 _0965_ sky130_fd_sc_hd__clkbuf_8
X_3487_ u_timer.threshold_reg\[24\] vssd1 vssd1 vccd1 vccd1 _1747_ sky130_fd_sc_hd__inv_2
XFILLER_0_51_3 vccd1 vssd1 vccd1 vssd1 sky130_ef_sc_hd__decap_12
X_2438_ u_core.u_regfile.rf\[31\]\[25\] _0895_ _0874_ _0738_ vssd1 vssd1 vccd1 vccd1
+ _0896_ sky130_fd_sc_hd__a2bb2o_1
X_2369_ u_core.u_regfile.rf\[29\]\[25\] u_core.u_regfile.rf\[31\]\[25\] _0705_ vssd1
+ vssd1 vccd1 vccd1 _0827_ sky130_fd_sc_hd__mux2_1
X_4108_ net147 vssd1 vssd1 vccd1 vccd1 _2050_ sky130_fd_sc_hd__clkbuf_1
X_4039_ _2015_ vssd1 vssd1 vccd1 vccd1 _0482_ sky130_fd_sc_hd__clkbuf_1
XFILLER_0_78_153 vssd1 vssd1 vccd1 vccd1 sky130_fd_sc_hd__decap_8
XFILLER_0_2_82 vssd1 vssd1 vccd1 vccd1 sky130_fd_sc_hd__fill_2
XFILLER_0_78_197 vssd1 vssd1 vccd1 vccd1 sky130_fd_sc_hd__decap_8
XPHY_104 vssd1 vssd1 vccd1 vccd1 sky130_fd_sc_hd__decap_3
XPHY_115 vssd1 vssd1 vccd1 vccd1 sky130_fd_sc_hd__decap_3
XPHY_148 vssd1 vssd1 vccd1 vccd1 sky130_fd_sc_hd__decap_3
XFILLER_0_19_242 vssd1 vssd1 vccd1 vccd1 sky130_fd_sc_hd__fill_1
XPHY_126 vssd1 vssd1 vccd1 vccd1 sky130_fd_sc_hd__decap_3
XPHY_137 vssd1 vssd1 vccd1 vccd1 sky130_fd_sc_hd__decap_3
XPHY_159 vssd1 vssd1 vccd1 vccd1 sky130_fd_sc_hd__decap_3
XFILLER_0_30_462 vssd1 vssd1 vccd1 vccd1 sky130_fd_sc_hd__fill_1
XFILLER_0_43_27 vccd1 vssd1 vccd1 vssd1 sky130_ef_sc_hd__decap_12
XPHY_6 vssd1 vssd1 vccd1 vccd1 sky130_fd_sc_hd__decap_3
XFILLER_0_57_315 vccd1 vssd1 vccd1 vssd1 sky130_ef_sc_hd__decap_12
XFILLER_0_84_145 vssd1 vssd1 vccd1 vccd1 sky130_fd_sc_hd__fill_1
XFILLER_0_57_337 vssd1 vssd1 vccd1 vccd1 sky130_fd_sc_hd__fill_1
XFILLER_0_84_156 vssd1 vssd1 vccd1 vccd1 sky130_fd_sc_hd__decap_3
XFILLER_0_72_329 vssd1 vssd1 vccd1 vccd1 sky130_fd_sc_hd__decap_3
XFILLER_0_65_370 vssd1 vssd1 vccd1 vccd1 sky130_fd_sc_hd__fill_1
XFILLER_0_25_267 vssd1 vssd1 vccd1 vccd1 sky130_fd_sc_hd__fill_2
XFILLER_0_13_429 vssd1 vssd1 vccd1 vccd1 sky130_fd_sc_hd__fill_2
XFILLER_0_7_27 vccd1 vssd1 vccd1 vssd1 sky130_ef_sc_hd__decap_12
Xhold308 u_core.u_regfile.rf\[26\]\[5\] vssd1 vssd1 vccd1 vccd1 net341 sky130_fd_sc_hd__dlygate4sd3_1
X_3410_ _0640_ _1680_ _1691_ vssd1 vssd1 vccd1 vccd1 _0177_ sky130_fd_sc_hd__a21oi_1
X_4390_ clknet_leaf_16_clk _0201_ net28 vssd1 vssd1 vccd1 vccd1 u_timer.threshold_reg\[26\]
+ sky130_fd_sc_hd__dfrtp_1
Xhold319 u_core.u_regfile.rf\[2\]\[9\] vssd1 vssd1 vccd1 vccd1 net352 sky130_fd_sc_hd__dlygate4sd3_1
X_3341_ _1661_ vssd1 vssd1 vccd1 vccd1 _0138_ sky130_fd_sc_hd__clkbuf_1
XFILLER_0_68_57 vssd1 vssd1 vccd1 vccd1 sky130_fd_sc_hd__fill_1
XTAP_602 vssd1 vccd1 sky130_fd_sc_hd__tapvpwrvgnd_1
XTAP_613 vssd1 vccd1 sky130_fd_sc_hd__tapvpwrvgnd_1
XTAP_624 vssd1 vccd1 sky130_fd_sc_hd__tapvpwrvgnd_1
X_3272_ _1629_ _1630_ _1631_ net130 vssd1 vssd1 vccd1 vccd1 _0099_ sky130_fd_sc_hd__o31a_1
XTAP_635 vssd1 vccd1 sky130_fd_sc_hd__tapvpwrvgnd_1
XTAP_646 vssd1 vccd1 sky130_fd_sc_hd__tapvpwrvgnd_1
XTAP_657 vssd1 vccd1 sky130_fd_sc_hd__tapvpwrvgnd_1
XTAP_668 vssd1 vccd1 sky130_fd_sc_hd__tapvpwrvgnd_1
X_2223_ _0581_ _0594_ _0680_ _0681_ vssd1 vssd1 vccd1 vccd1 _0682_ sky130_fd_sc_hd__or4_1
XTAP_679 vssd1 vccd1 sky130_fd_sc_hd__tapvpwrvgnd_1
X_2154_ u_timer.count_reg\[14\] vssd1 vssd1 vccd1 vccd1 _0613_ sky130_fd_sc_hd__inv_2
XFILLER_0_48_348 vssd1 vssd1 vccd1 vccd1 sky130_fd_sc_hd__decap_4
XFILLER_0_75_156 vssd1 vssd1 vccd1 vccd1 sky130_fd_sc_hd__decap_4
XFILLER_0_8_445 vssd1 vssd1 vccd1 vccd1 sky130_fd_sc_hd__decap_6
X_2987_ _1150_ _1366_ _1000_ vssd1 vssd1 vccd1 vccd1 _1445_ sky130_fd_sc_hd__o21ai_1
XFILLER_0_56_381 vssd1 vssd1 vccd1 vccd1 sky130_fd_sc_hd__fill_1
X_4726_ clknet_leaf_7_clk _0527_ net23 vssd1 vssd1 vccd1 vccd1 net3 sky130_fd_sc_hd__dfrtp_4
XFILLER_0_71_362 vssd1 vssd1 vccd1 vccd1 sky130_fd_sc_hd__decap_4
X_4657_ clknet_leaf_24_clk _0458_ vssd1 vssd1 vccd1 vccd1 u_core.u_regfile.rf\[26\]\[27\]
+ sky130_fd_sc_hd__dfxtp_1
X_3608_ _1487_ _1486_ _0778_ net95 vssd1 vssd1 vccd1 vccd1 _0270_ sky130_fd_sc_hd__o31a_1
X_4588_ clknet_leaf_23_clk _0389_ vssd1 vssd1 vccd1 vccd1 u_core.u_regfile.rf\[27\]\[22\]
+ sky130_fd_sc_hd__dfxtp_1
XFILLER_0_12_495 vssd1 vssd1 vccd1 vccd1 sky130_fd_sc_hd__fill_1
X_3539_ _1774_ vssd1 vssd1 vccd1 vccd1 _0223_ sky130_fd_sc_hd__clkbuf_1
XFILLER_0_22_237 vssd1 vssd1 vccd1 vccd1 sky130_fd_sc_hd__fill_1
XFILLER_0_38_27 vssd1 vssd1 vccd1 vccd1 sky130_fd_sc_hd__fill_1
XFILLER_0_54_15 vccd1 vssd1 vccd1 vssd1 sky130_ef_sc_hd__decap_12
XFILLER_0_85_421 vssd1 vssd1 vccd1 vccd1 sky130_fd_sc_hd__decap_8
X_2910_ _1367_ _1340_ _1291_ vssd1 vssd1 vccd1 vccd1 _1368_ sky130_fd_sc_hd__a21boi_2
X_3890_ net480 vssd1 vssd1 vccd1 vccd1 _1941_ sky130_fd_sc_hd__clkbuf_1
XFILLER_0_5_404 vssd1 vssd1 vccd1 vccd1 sky130_fd_sc_hd__decap_4
X_2841_ _1294_ _1295_ _1298_ _0850_ vssd1 vssd1 vccd1 vccd1 _1299_ sky130_fd_sc_hd__o211ai_4
X_2772_ _0913_ u_core.u_regfile.rf\[1\]\[21\] _0858_ _0914_ vssd1 vssd1 vccd1 vccd1
+ _1230_ sky130_fd_sc_hd__a31o_1
X_4511_ clknet_leaf_38_clk _0312_ vssd1 vssd1 vccd1 vccd1 u_core.u_regfile.rf\[2\]\[9\]
+ sky130_fd_sc_hd__dfxtp_1
X_4442_ clknet_leaf_50_clk _0243_ vssd1 vssd1 vccd1 vccd1 u_core.u_regfile.rf\[7\]\[4\]
+ sky130_fd_sc_hd__dfxtp_1
Xhold116 u_core.u_regfile.rf\[30\]\[10\] vssd1 vssd1 vccd1 vccd1 net149 sky130_fd_sc_hd__dlygate4sd3_1
Xhold105 u_core.u_regfile.rf\[24\]\[31\] vssd1 vssd1 vccd1 vccd1 net138 sky130_fd_sc_hd__dlygate4sd3_1
Xhold127 u_core.u_regfile.rf\[26\]\[0\] vssd1 vssd1 vccd1 vccd1 net160 sky130_fd_sc_hd__dlygate4sd3_1
Xhold149 u_core.u_regfile.rf\[3\]\[21\] vssd1 vssd1 vccd1 vccd1 net182 sky130_fd_sc_hd__dlygate4sd3_1
Xhold138 u_core.u_regfile.rf\[2\]\[5\] vssd1 vssd1 vccd1 vccd1 net171 sky130_fd_sc_hd__dlygate4sd3_1
XFILLER_0_0_153 vssd1 vssd1 vccd1 vccd1 sky130_fd_sc_hd__decap_6
X_4373_ clknet_leaf_15_clk _0184_ net27 vssd1 vssd1 vccd1 vccd1 u_timer.threshold_reg\[9\]
+ sky130_fd_sc_hd__dfrtp_1
XFILLER_0_0_197 vccd1 vssd1 vccd1 vssd1 sky130_ef_sc_hd__decap_12
X_3324_ net413 vssd1 vssd1 vccd1 vccd1 _1653_ sky130_fd_sc_hd__clkbuf_1
XTAP_410 vssd1 vccd1 sky130_fd_sc_hd__tapvpwrvgnd_1
XTAP_421 vssd1 vccd1 sky130_fd_sc_hd__tapvpwrvgnd_1
XTAP_432 vssd1 vccd1 sky130_fd_sc_hd__tapvpwrvgnd_1
X_3255_ _1623_ _1624_ _1625_ net126 vssd1 vssd1 vccd1 vccd1 _0088_ sky130_fd_sc_hd__o31a_1
XTAP_443 vssd1 vccd1 sky130_fd_sc_hd__tapvpwrvgnd_1
XTAP_454 vssd1 vccd1 sky130_fd_sc_hd__tapvpwrvgnd_1
XTAP_465 vssd1 vccd1 sky130_fd_sc_hd__tapvpwrvgnd_1
XTAP_476 vssd1 vccd1 sky130_fd_sc_hd__tapvpwrvgnd_1
X_2206_ u_timer.threshold_reg\[20\] _0663_ u_timer.threshold_reg\[21\] _0664_ vssd1
+ vssd1 vccd1 vccd1 _0665_ sky130_fd_sc_hd__o22a_1
XTAP_487 vssd1 vccd1 sky130_fd_sc_hd__tapvpwrvgnd_1
XTAP_498 vssd1 vccd1 sky130_fd_sc_hd__tapvpwrvgnd_1
X_3186_ _1594_ vssd1 vssd1 vccd1 vccd1 _0050_ sky130_fd_sc_hd__clkbuf_1
X_2137_ _0586_ _0587_ _0594_ _0593_ _0595_ vssd1 vssd1 vccd1 vccd1 _0596_ sky130_fd_sc_hd__o32a_1
XFILLER_0_14_3 vccd1 vssd1 vccd1 vssd1 sky130_ef_sc_hd__decap_12
XFILLER_0_76_410 vssd1 vssd1 vccd1 vccd1 sky130_fd_sc_hd__decap_8
XFILLER_0_76_421 vssd1 vssd1 vccd1 vccd1 sky130_fd_sc_hd__decap_8
XFILLER_0_48_145 vssd1 vssd1 vccd1 vccd1 sky130_fd_sc_hd__fill_2
XFILLER_0_8_253 vssd1 vssd1 vccd1 vccd1 sky130_fd_sc_hd__decap_6
X_4709_ clknet_leaf_34_clk _0510_ vssd1 vssd1 vccd1 vccd1 u_core.u_regfile.rf\[25\]\[15\]
+ sky130_fd_sc_hd__dfxtp_1
XFILLER_0_44_373 vssd1 vssd1 vccd1 vccd1 sky130_fd_sc_hd__fill_2
XFILLER_0_79_281 vssd1 vssd1 vccd1 vccd1 sky130_fd_sc_hd__fill_2
XFILLER_0_82_413 vssd1 vssd1 vccd1 vccd1 sky130_fd_sc_hd__decap_6
XFILLER_0_67_498 vssd1 vssd1 vccd1 vccd1 sky130_fd_sc_hd__decap_6
XFILLER_0_82_457 vccd1 vssd1 vccd1 vssd1 sky130_ef_sc_hd__decap_12
XFILLER_0_49_15 vccd1 vssd1 vccd1 vssd1 sky130_ef_sc_hd__decap_12
X_3040_ net524 net513 _1491_ vssd1 vssd1 vccd1 vccd1 _0018_ sky130_fd_sc_hd__a21oi_1
XFILLER_0_65_69 vssd1 vssd1 vccd1 vccd1 sky130_fd_sc_hd__decap_4
XFILLER_0_81_57 vccd1 vssd1 vccd1 vssd1 sky130_ef_sc_hd__decap_12
XFILLER_0_58_432 vssd1 vssd1 vccd1 vccd1 sky130_fd_sc_hd__decap_6
XFILLER_0_85_240 vccd1 vssd1 vccd1 vssd1 sky130_ef_sc_hd__decap_12
XFILLER_0_18_307 vssd1 vssd1 vccd1 vccd1 sky130_fd_sc_hd__fill_1
X_3942_ net342 vssd1 vssd1 vccd1 vccd1 _1967_ sky130_fd_sc_hd__clkbuf_1
XFILLER_0_73_413 vccd1 vssd1 vccd1 vssd1 sky130_ef_sc_hd__decap_12
X_3873_ _1932_ vssd1 vssd1 vccd1 vccd1 _0399_ sky130_fd_sc_hd__clkbuf_1
X_2824_ _1239_ _1245_ _1250_ _1255_ vssd1 vssd1 vccd1 vccd1 _1282_ sky130_fd_sc_hd__o31a_1
XFILLER_0_5_289 vssd1 vssd1 vccd1 vccd1 sky130_fd_sc_hd__decap_3
XFILLER_0_30_83 vssd1 vssd1 vccd1 vccd1 sky130_fd_sc_hd__fill_1
X_2755_ u_core.u_regfile.rf\[5\]\[20\] _0733_ _0904_ _0770_ _0773_ vssd1 vssd1 vccd1
+ vccd1 _1213_ sky130_fd_sc_hd__o32a_1
X_2686_ _0735_ _0963_ _0964_ _0957_ vssd1 vssd1 vccd1 vccd1 _1144_ sky130_fd_sc_hd__a31o_1
X_4425_ clknet_leaf_7_clk _0236_ vssd1 vssd1 vccd1 vccd1 u_core.u_regfile.rf\[29\]\[29\]
+ sky130_fd_sc_hd__dfxtp_1
XFILLER_0_1_473 vccd1 vssd1 vccd1 vssd1 sky130_ef_sc_hd__decap_12
X_4356_ clknet_leaf_28_clk _0167_ vssd1 vssd1 vccd1 vccd1 u_core.u_regfile.rf\[5\]\[24\]
+ sky130_fd_sc_hd__dfxtp_1
X_3307_ _1644_ vssd1 vssd1 vccd1 vccd1 _0121_ sky130_fd_sc_hd__clkbuf_1
XTAP_251 vssd1 vccd1 sky130_fd_sc_hd__tapvpwrvgnd_1
XTAP_240 vssd1 vccd1 sky130_fd_sc_hd__tapvpwrvgnd_1
XTAP_284 vssd1 vccd1 sky130_fd_sc_hd__tapvpwrvgnd_1
XTAP_273 vssd1 vccd1 sky130_fd_sc_hd__tapvpwrvgnd_1
XTAP_262 vssd1 vccd1 sky130_fd_sc_hd__tapvpwrvgnd_1
X_4287_ clknet_leaf_47_clk _0098_ vssd1 vssd1 vccd1 vccd1 u_core.u_regfile.rf\[6\]\[19\]
+ sky130_fd_sc_hd__dfxtp_1
XTAP_295 vssd1 vccd1 sky130_fd_sc_hd__tapvpwrvgnd_1
X_3238_ _1620_ vssd1 vssd1 vccd1 vccd1 _0076_ sky130_fd_sc_hd__clkbuf_1
X_3169_ net501 _1583_ vssd1 vssd1 vccd1 vccd1 _1586_ sky130_fd_sc_hd__nor2_1
Xfanout22 net23 vssd1 vssd1 vccd1 vccd1 net22 sky130_fd_sc_hd__clkbuf_2
XFILLER_0_76_295 vssd1 vssd1 vccd1 vccd1 sky130_fd_sc_hd__decap_6
XFILLER_0_76_273 vssd1 vssd1 vccd1 vccd1 sky130_fd_sc_hd__fill_1
Xfanout33 net1 vssd1 vssd1 vccd1 vccd1 net33 sky130_fd_sc_hd__clkbuf_4
XFILLER_0_32_365 vssd1 vssd1 vccd1 vccd1 sky130_fd_sc_hd__decap_4
Xhold480 u_timer.count_reg\[0\] vssd1 vssd1 vccd1 vccd1 net513 sky130_fd_sc_hd__dlygate4sd3_1
XFILLER_0_3_3 vccd1 vssd1 vccd1 vssd1 sky130_ef_sc_hd__decap_12
Xhold491 u_timer.count_reg\[1\] vssd1 vssd1 vccd1 vccd1 net524 sky130_fd_sc_hd__dlygate4sd3_1
XFILLER_0_59_229 vssd1 vssd1 vccd1 vccd1 sky130_fd_sc_hd__decap_8
XFILLER_0_51_27 vccd1 vssd1 vccd1 vssd1 sky130_ef_sc_hd__decap_12
XFILLER_0_67_251 vssd1 vssd1 vccd1 vccd1 sky130_fd_sc_hd__fill_2
XFILLER_0_55_435 vssd1 vssd1 vccd1 vccd1 sky130_fd_sc_hd__decap_6
X_2540_ _0735_ _0987_ _0988_ _0996_ _0997_ vssd1 vssd1 vccd1 vccd1 _0998_ sky130_fd_sc_hd__a41oi_4
XFILLER_0_23_387 vssd1 vssd1 vccd1 vccd1 sky130_fd_sc_hd__decap_4
X_2471_ _0928_ u_core.u_regfile.rf\[28\]\[15\] _0696_ vssd1 vssd1 vccd1 vccd1 _0929_
+ sky130_fd_sc_hd__mux2_1
X_4210_ net260 vssd1 vssd1 vccd1 vccd1 _2105_ sky130_fd_sc_hd__clkbuf_1
XFILLER_0_50_195 vssd1 vssd1 vccd1 vccd1 sky130_fd_sc_hd__fill_1
X_4141_ net531 _2062_ _2069_ _2061_ vssd1 vssd1 vccd1 vccd1 _0530_ sky130_fd_sc_hd__o2bb2ai_1
X_4072_ net330 vssd1 vssd1 vccd1 vccd1 _2032_ sky130_fd_sc_hd__clkbuf_1
X_3023_ _1332_ _1413_ net13 _1480_ vssd1 vssd1 vccd1 vccd1 _1481_ sky130_fd_sc_hd__nand4_4
XFILLER_0_25_94 vssd1 vssd1 vccd1 vccd1 sky130_fd_sc_hd__fill_2
XFILLER_0_58_240 vssd1 vssd1 vccd1 vccd1 sky130_fd_sc_hd__fill_2
X_3925_ _1958_ vssd1 vssd1 vccd1 vccd1 _0425_ sky130_fd_sc_hd__clkbuf_1
XFILLER_0_58_284 vssd1 vssd1 vccd1 vccd1 sky130_fd_sc_hd__fill_1
X_3856_ net250 vssd1 vssd1 vccd1 vccd1 _1924_ sky130_fd_sc_hd__clkbuf_1
XFILLER_0_81_3 vccd1 vssd1 vccd1 vssd1 sky130_ef_sc_hd__decap_12
X_2807_ _1263_ _0952_ _1264_ vssd1 vssd1 vccd1 vccd1 _1265_ sky130_fd_sc_hd__a21oi_2
X_3787_ _1861_ _1364_ _1369_ _1889_ vssd1 vssd1 vccd1 vccd1 _0356_ sky130_fd_sc_hd__o31ai_1
X_2738_ _0700_ _0861_ u_core.u_regfile.rf\[4\]\[17\] vssd1 vssd1 vccd1 vccd1 _1196_
+ sky130_fd_sc_hd__a21o_1
X_4408_ clknet_leaf_42_clk _0219_ vssd1 vssd1 vccd1 vccd1 u_core.u_regfile.rf\[29\]\[12\]
+ sky130_fd_sc_hd__dfxtp_1
X_2669_ _1119_ _0965_ _1125_ _1126_ vssd1 vssd1 vccd1 vccd1 _1127_ sky130_fd_sc_hd__nand4_1
XFILLER_0_1_281 vccd1 vssd1 vccd1 vssd1 sky130_ef_sc_hd__decap_12
X_4339_ clknet_leaf_4_clk _0150_ vssd1 vssd1 vccd1 vccd1 u_core.u_regfile.rf\[5\]\[7\]
+ sky130_fd_sc_hd__dfxtp_1
XFILLER_0_69_505 vssd1 vssd1 vccd1 vccd1 sky130_fd_sc_hd__decap_4
XFILLER_0_37_413 vssd1 vssd1 vccd1 vccd1 sky130_fd_sc_hd__fill_1
XFILLER_0_64_210 vssd1 vssd1 vccd1 vccd1 sky130_fd_sc_hd__decap_3
XFILLER_0_9_370 vssd1 vssd1 vccd1 vccd1 sky130_fd_sc_hd__fill_1
XFILLER_0_64_265 vccd1 vssd1 vccd1 vssd1 sky130_ef_sc_hd__decap_12
XFILLER_0_46_27 vssd1 vssd1 vccd1 vccd1 sky130_fd_sc_hd__fill_1
XFILLER_0_62_15 vccd1 vssd1 vccd1 vssd1 sky130_ef_sc_hd__decap_12
X_3710_ _1847_ vssd1 vssd1 vccd1 vccd1 _0321_ sky130_fd_sc_hd__clkbuf_1
X_4690_ clknet_leaf_37_clk _0491_ vssd1 vssd1 vccd1 vccd1 u_core.u_regfile.rf\[24\]\[28\]
+ sky130_fd_sc_hd__dfxtp_1
XFILLER_0_15_129 vssd1 vssd1 vccd1 vccd1 sky130_fd_sc_hd__fill_1
X_3641_ net162 vssd1 vssd1 vccd1 vccd1 _1813_ sky130_fd_sc_hd__clkbuf_1
XFILLER_0_70_213 vssd1 vssd1 vccd1 vccd1 sky130_fd_sc_hd__fill_2
X_3572_ _1632_ _1633_ _1790_ net113 vssd1 vssd1 vccd1 vccd1 _0240_ sky130_fd_sc_hd__o31a_1
XFILLER_0_11_52 vssd1 vssd1 vccd1 vccd1 sky130_fd_sc_hd__decap_4
X_2523_ u_core.u_regfile.rf\[31\]\[10\] _0726_ _0874_ _0738_ vssd1 vssd1 vccd1 vccd1
+ _0981_ sky130_fd_sc_hd__a2bb2o_1
X_2454_ _0881_ _0714_ u_core.u_regfile.rf\[4\]\[13\] vssd1 vssd1 vccd1 vccd1 _0912_
+ sky130_fd_sc_hd__a21o_1
X_2385_ u_core.u_regfile.rf\[28\]\[24\] _0697_ _0701_ _0703_ _0842_ vssd1 vssd1 vccd1
+ vccd1 _0843_ sky130_fd_sc_hd__a221o_1
X_4124_ net311 vssd1 vssd1 vccd1 vccd1 _2058_ sky130_fd_sc_hd__clkbuf_1
Xinput1 rst_n vssd1 vssd1 vccd1 vccd1 net1 sky130_fd_sc_hd__buf_1
Xclkbuf_leaf_48_clk clknet_2_0__leaf_clk vssd1 vssd1 vccd1 vccd1 clknet_leaf_48_clk
+ sky130_fd_sc_hd__clkbuf_16
X_4055_ _2023_ vssd1 vssd1 vccd1 vccd1 _0490_ sky130_fd_sc_hd__clkbuf_1
XFILLER_0_78_313 vssd1 vssd1 vccd1 vccd1 sky130_fd_sc_hd__fill_1
XFILLER_0_36_93 vssd1 vssd1 vccd1 vccd1 sky130_fd_sc_hd__fill_2
X_3006_ _1455_ _1463_ _0873_ vssd1 vssd1 vccd1 vccd1 _1464_ sky130_fd_sc_hd__o21bai_4
XFILLER_0_78_368 vccd1 vssd1 vccd1 vssd1 sky130_ef_sc_hd__decap_12
XFILLER_0_19_446 vssd1 vssd1 vccd1 vccd1 sky130_fd_sc_hd__fill_2
X_3908_ net422 vssd1 vssd1 vccd1 vccd1 _1950_ sky130_fd_sc_hd__clkbuf_1
X_3839_ _1915_ vssd1 vssd1 vccd1 vccd1 _0382_ sky130_fd_sc_hd__clkbuf_1
Xclkbuf_leaf_39_clk clknet_2_1__leaf_clk vssd1 vssd1 vccd1 vccd1 clknet_leaf_39_clk
+ sky130_fd_sc_hd__clkbuf_16
XFILLER_0_69_357 vssd1 vssd1 vccd1 vccd1 sky130_fd_sc_hd__decap_6
XFILLER_0_69_379 vssd1 vssd1 vccd1 vccd1 sky130_fd_sc_hd__fill_1
XFILLER_0_32_29 vssd1 vssd1 vccd1 vccd1 sky130_fd_sc_hd__fill_2
XFILLER_0_37_221 vssd1 vssd1 vccd1 vccd1 sky130_fd_sc_hd__decap_3
XFILLER_0_25_438 vssd1 vssd1 vccd1 vccd1 sky130_fd_sc_hd__fill_1
XFILLER_0_52_213 vssd1 vssd1 vccd1 vccd1 sky130_fd_sc_hd__decap_3
XFILLER_0_0_505 vssd1 vssd1 vccd1 vccd1 sky130_fd_sc_hd__decap_4
XFILLER_0_57_15 vccd1 vssd1 vccd1 vssd1 sky130_ef_sc_hd__decap_12
XTAP_806 vssd1 vccd1 sky130_fd_sc_hd__tapvpwrvgnd_1
XTAP_817 vssd1 vccd1 sky130_fd_sc_hd__tapvpwrvgnd_1
XTAP_839 vssd1 vccd1 sky130_fd_sc_hd__tapvpwrvgnd_1
XTAP_828 vssd1 vccd1 sky130_fd_sc_hd__tapvpwrvgnd_1
X_2170_ _0627_ u_timer.count_reg\[8\] _0628_ u_timer.count_reg\[9\] vssd1 vssd1 vccd1
+ vccd1 _0629_ sky130_fd_sc_hd__a22o_1
XFILLER_0_73_69 vccd1 vssd1 vccd1 vssd1 sky130_ef_sc_hd__decap_12
XFILLER_0_48_508 vssd1 vssd1 vccd1 vccd1 sky130_fd_sc_hd__fill_2
X_4742_ clknet_leaf_15_clk _0037_ net28 vssd1 vssd1 vccd1 vccd1 u_timer.count_reg\[8\]
+ sky130_fd_sc_hd__dfrtp_4
XFILLER_0_83_393 vccd1 vssd1 vccd1 vssd1 sky130_ef_sc_hd__decap_12
X_4673_ clknet_leaf_27_clk _0474_ vssd1 vssd1 vccd1 vccd1 u_core.u_regfile.rf\[24\]\[11\]
+ sky130_fd_sc_hd__dfxtp_1
X_3624_ _1804_ vssd1 vssd1 vccd1 vccd1 _0278_ sky130_fd_sc_hd__clkbuf_1
X_3555_ _1782_ vssd1 vssd1 vccd1 vccd1 _0231_ sky130_fd_sc_hd__clkbuf_1
X_2506_ u_core.u_regfile.rf\[31\]\[8\] _0895_ _0745_ _0803_ vssd1 vssd1 vccd1 vccd1
+ _0964_ sky130_fd_sc_hd__o22a_2
X_3486_ _1253_ _1741_ _1746_ vssd1 vssd1 vccd1 vccd1 _0198_ sky130_fd_sc_hd__o21ai_1
X_2437_ _0725_ vssd1 vssd1 vccd1 vccd1 _0895_ sky130_fd_sc_hd__buf_4
XFILLER_0_44_3 vccd1 vssd1 vccd1 vssd1 sky130_ef_sc_hd__decap_12
X_2368_ _0743_ _0824_ _0825_ vssd1 vssd1 vccd1 vccd1 _0826_ sky130_fd_sc_hd__o21ai_4
X_4107_ _2049_ vssd1 vssd1 vccd1 vccd1 _0516_ sky130_fd_sc_hd__clkbuf_1
X_2299_ _0729_ vssd1 vssd1 vccd1 vccd1 _0757_ sky130_fd_sc_hd__clkbuf_4
XFILLER_0_47_92 vssd1 vssd1 vccd1 vccd1 sky130_fd_sc_hd__fill_1
X_4038_ net325 vssd1 vssd1 vccd1 vccd1 _2015_ sky130_fd_sc_hd__clkbuf_1
XPHY_105 vssd1 vssd1 vccd1 vccd1 sky130_fd_sc_hd__decap_3
XPHY_116 vssd1 vssd1 vccd1 vccd1 sky130_fd_sc_hd__decap_3
XPHY_149 vssd1 vssd1 vccd1 vccd1 sky130_fd_sc_hd__decap_3
XPHY_127 vssd1 vssd1 vccd1 vccd1 sky130_fd_sc_hd__decap_3
XPHY_138 vssd1 vssd1 vccd1 vccd1 sky130_fd_sc_hd__decap_3
XFILLER_0_74_393 vssd1 vssd1 vccd1 vccd1 sky130_fd_sc_hd__fill_1
XFILLER_0_30_474 vssd1 vssd1 vccd1 vccd1 sky130_fd_sc_hd__fill_2
XFILLER_0_69_110 vssd1 vssd1 vccd1 vccd1 sky130_fd_sc_hd__fill_2
XPHY_7 vssd1 vssd1 vccd1 vccd1 sky130_fd_sc_hd__decap_3
XFILLER_0_43_39 vssd1 vssd1 vccd1 vccd1 sky130_fd_sc_hd__decap_6
XFILLER_0_57_327 vssd1 vssd1 vccd1 vccd1 sky130_fd_sc_hd__decap_3
XFILLER_0_57_349 vssd1 vssd1 vccd1 vccd1 sky130_fd_sc_hd__fill_1
XFILLER_0_65_360 vssd1 vssd1 vccd1 vccd1 sky130_fd_sc_hd__decap_6
XFILLER_0_65_393 vccd1 vssd1 vccd1 vssd1 sky130_ef_sc_hd__decap_12
XFILLER_0_25_279 vssd1 vssd1 vccd1 vccd1 sky130_fd_sc_hd__fill_1
XFILLER_0_7_39 vccd1 vssd1 vccd1 vssd1 sky130_ef_sc_hd__decap_12
XFILLER_0_33_290 vssd1 vssd1 vccd1 vccd1 sky130_fd_sc_hd__fill_1
Xhold309 u_core.u_regfile.rf\[26\]\[3\] vssd1 vssd1 vccd1 vccd1 net342 sky130_fd_sc_hd__dlygate4sd3_1
X_3340_ net453 vssd1 vssd1 vccd1 vccd1 _1661_ sky130_fd_sc_hd__clkbuf_1
XTAP_603 vssd1 vccd1 sky130_fd_sc_hd__tapvpwrvgnd_1
XTAP_614 vssd1 vccd1 sky130_fd_sc_hd__tapvpwrvgnd_1
XTAP_625 vssd1 vccd1 sky130_fd_sc_hd__tapvpwrvgnd_1
X_3271_ _1483_ vssd1 vssd1 vccd1 vccd1 _1631_ sky130_fd_sc_hd__buf_2
XTAP_636 vssd1 vccd1 sky130_fd_sc_hd__tapvpwrvgnd_1
XTAP_647 vssd1 vccd1 sky130_fd_sc_hd__tapvpwrvgnd_1
XTAP_658 vssd1 vccd1 sky130_fd_sc_hd__tapvpwrvgnd_1
X_2222_ _0597_ u_timer.threshold_reg\[28\] _0585_ u_timer.threshold_reg\[24\] _0587_
+ vssd1 vssd1 vccd1 vccd1 _0681_ sky130_fd_sc_hd__a221o_1
XTAP_669 vssd1 vccd1 sky130_fd_sc_hd__tapvpwrvgnd_1
X_2153_ u_timer.threshold_reg\[15\] vssd1 vssd1 vccd1 vccd1 _0612_ sky130_fd_sc_hd__inv_2
XFILLER_0_17_51 vssd1 vssd1 vccd1 vccd1 sky130_fd_sc_hd__fill_2
XFILLER_0_75_113 vssd1 vssd1 vccd1 vccd1 sky130_fd_sc_hd__decap_6
XFILLER_0_8_413 vssd1 vssd1 vccd1 vccd1 sky130_fd_sc_hd__decap_4
X_2986_ _1421_ _1422_ _1438_ _1443_ vssd1 vssd1 vccd1 vccd1 _1444_ sky130_fd_sc_hd__a211oi_2
X_4725_ clknet_leaf_38_clk _0526_ vssd1 vssd1 vccd1 vccd1 u_core.u_regfile.rf\[25\]\[31\]
+ sky130_fd_sc_hd__dfxtp_1
X_4656_ clknet_leaf_49_clk _0457_ vssd1 vssd1 vccd1 vccd1 u_core.u_regfile.rf\[26\]\[26\]
+ sky130_fd_sc_hd__dfxtp_1
X_4587_ clknet_leaf_35_clk _0388_ vssd1 vssd1 vccd1 vccd1 u_core.u_regfile.rf\[27\]\[21\]
+ sky130_fd_sc_hd__dfxtp_1
X_3607_ _1487_ _1486_ _0778_ net63 vssd1 vssd1 vccd1 vccd1 _0269_ sky130_fd_sc_hd__o31a_1
X_3538_ net416 vssd1 vssd1 vccd1 vccd1 _1774_ sky130_fd_sc_hd__clkbuf_1
X_3469_ _1464_ _1465_ _1458_ _1461_ _1676_ vssd1 vssd1 vccd1 vccd1 _1735_ sky130_fd_sc_hd__a221o_1
XFILLER_0_79_441 vssd1 vssd1 vccd1 vccd1 sky130_fd_sc_hd__decap_6
XFILLER_0_47_393 vssd1 vssd1 vccd1 vccd1 sky130_fd_sc_hd__decap_3
XFILLER_0_30_271 vssd1 vssd1 vccd1 vccd1 sky130_fd_sc_hd__decap_6
XFILLER_0_54_27 vssd1 vssd1 vccd1 vccd1 sky130_fd_sc_hd__fill_1
XFILLER_0_70_15 vccd1 vssd1 vccd1 vssd1 sky130_ef_sc_hd__decap_12
XFILLER_0_85_477 vccd1 vssd1 vccd1 vssd1 sky130_ef_sc_hd__decap_12
X_2840_ _0833_ _1297_ vssd1 vssd1 vccd1 vccd1 _1298_ sky130_fd_sc_hd__nor2_1
XFILLER_0_70_37 vssd1 vssd1 vccd1 vccd1 sky130_fd_sc_hd__decap_3
XFILLER_0_72_138 vssd1 vssd1 vccd1 vccd1 sky130_fd_sc_hd__fill_2
X_2771_ _0909_ _0803_ u_core.u_regfile.rf\[4\]\[21\] vssd1 vssd1 vccd1 vccd1 _1229_
+ sky130_fd_sc_hd__a21o_1
XFILLER_0_5_449 vccd1 vssd1 vccd1 vssd1 sky130_ef_sc_hd__decap_12
X_4510_ clknet_leaf_35_clk _0311_ vssd1 vssd1 vccd1 vccd1 u_core.u_regfile.rf\[2\]\[8\]
+ sky130_fd_sc_hd__dfxtp_1
XFILLER_0_79_57 vccd1 vssd1 vccd1 vssd1 sky130_ef_sc_hd__decap_12
Xhold117 u_core.u_regfile.rf\[26\]\[10\] vssd1 vssd1 vccd1 vccd1 net150 sky130_fd_sc_hd__dlygate4sd3_1
X_4441_ clknet_leaf_50_clk _0242_ vssd1 vssd1 vccd1 vccd1 u_core.u_regfile.rf\[7\]\[3\]
+ sky130_fd_sc_hd__dfxtp_1
Xhold106 u_core.u_regfile.rf\[6\]\[22\] vssd1 vssd1 vccd1 vccd1 net139 sky130_fd_sc_hd__dlygate4sd3_1
Xhold128 u_core.u_regfile.rf\[27\]\[30\] vssd1 vssd1 vccd1 vccd1 net161 sky130_fd_sc_hd__dlygate4sd3_1
Xhold139 u_core.u_regfile.rf\[24\]\[30\] vssd1 vssd1 vccd1 vccd1 net172 sky130_fd_sc_hd__dlygate4sd3_1
XTAP_400 vssd1 vccd1 sky130_fd_sc_hd__tapvpwrvgnd_1
X_4372_ clknet_leaf_20_clk _0183_ net27 vssd1 vssd1 vccd1 vccd1 u_timer.threshold_reg\[8\]
+ sky130_fd_sc_hd__dfrtp_1
X_3323_ _1652_ vssd1 vssd1 vccd1 vccd1 _0129_ sky130_fd_sc_hd__clkbuf_1
XTAP_411 vssd1 vccd1 sky130_fd_sc_hd__tapvpwrvgnd_1
XTAP_422 vssd1 vccd1 sky130_fd_sc_hd__tapvpwrvgnd_1
XTAP_433 vssd1 vccd1 sky130_fd_sc_hd__tapvpwrvgnd_1
X_3254_ _1623_ _1624_ _1625_ net125 vssd1 vssd1 vccd1 vccd1 _0087_ sky130_fd_sc_hd__o31a_1
XTAP_444 vssd1 vccd1 sky130_fd_sc_hd__tapvpwrvgnd_1
XTAP_455 vssd1 vccd1 sky130_fd_sc_hd__tapvpwrvgnd_1
XTAP_466 vssd1 vccd1 sky130_fd_sc_hd__tapvpwrvgnd_1
X_2205_ net563 vssd1 vssd1 vccd1 vccd1 _0664_ sky130_fd_sc_hd__inv_2
XTAP_477 vssd1 vccd1 sky130_fd_sc_hd__tapvpwrvgnd_1
XTAP_488 vssd1 vccd1 sky130_fd_sc_hd__tapvpwrvgnd_1
XTAP_499 vssd1 vccd1 sky130_fd_sc_hd__tapvpwrvgnd_1
X_3185_ net465 vssd1 vssd1 vccd1 vccd1 _1594_ sky130_fd_sc_hd__clkbuf_1
X_2136_ u_timer.count_reg\[27\] _0588_ vssd1 vssd1 vccd1 vccd1 _0595_ sky130_fd_sc_hd__nor2_1
XFILLER_0_76_477 vccd1 vssd1 vccd1 vssd1 sky130_ef_sc_hd__decap_12
XFILLER_0_17_500 vssd1 vssd1 vccd1 vccd1 sky130_fd_sc_hd__decap_4
XFILLER_0_29_393 vssd1 vssd1 vccd1 vccd1 sky130_fd_sc_hd__fill_1
X_2969_ _1049_ _1426_ _1034_ vssd1 vssd1 vccd1 vccd1 _1427_ sky130_fd_sc_hd__a21boi_1
X_4708_ clknet_leaf_36_clk _0509_ vssd1 vssd1 vccd1 vccd1 u_core.u_regfile.rf\[25\]\[14\]
+ sky130_fd_sc_hd__dfxtp_1
XFILLER_0_44_352 vssd1 vssd1 vccd1 vccd1 sky130_fd_sc_hd__fill_1
XFILLER_0_44_363 vssd1 vssd1 vccd1 vccd1 sky130_fd_sc_hd__fill_1
X_4639_ clknet_leaf_22_clk _0440_ vssd1 vssd1 vccd1 vccd1 u_core.u_regfile.rf\[26\]\[9\]
+ sky130_fd_sc_hd__dfxtp_1
XFILLER_0_39_113 vssd1 vssd1 vccd1 vccd1 sky130_fd_sc_hd__fill_2
XFILLER_0_82_469 vssd1 vssd1 vccd1 vccd1 sky130_fd_sc_hd__decap_6
XFILLER_0_40_29 vssd1 vssd1 vccd1 vccd1 sky130_fd_sc_hd__fill_1
XFILLER_0_23_503 vssd1 vssd1 vccd1 vccd1 sky130_fd_sc_hd__fill_1
XFILLER_0_2_419 vssd1 vssd1 vccd1 vccd1 sky130_fd_sc_hd__fill_1
XFILLER_0_35_385 vssd1 vssd1 vccd1 vccd1 sky130_fd_sc_hd__decap_4
XFILLER_0_49_27 vccd1 vssd1 vccd1 vssd1 sky130_ef_sc_hd__decap_12
XFILLER_0_65_37 vssd1 vssd1 vccd1 vccd1 sky130_fd_sc_hd__fill_1
XFILLER_0_81_69 vccd1 vssd1 vccd1 vssd1 sky130_ef_sc_hd__decap_12
XFILLER_0_73_403 vssd1 vssd1 vccd1 vccd1 sky130_fd_sc_hd__decap_6
X_3941_ _1966_ vssd1 vssd1 vccd1 vccd1 _0433_ sky130_fd_sc_hd__clkbuf_1
XFILLER_0_14_52 vssd1 vssd1 vccd1 vccd1 sky130_fd_sc_hd__decap_4
XFILLER_0_73_425 vccd1 vssd1 vccd1 vssd1 sky130_ef_sc_hd__decap_12
XFILLER_0_14_96 vssd1 vssd1 vccd1 vccd1 sky130_fd_sc_hd__decap_8
X_3872_ net394 vssd1 vssd1 vccd1 vccd1 _1932_ sky130_fd_sc_hd__clkbuf_1
XFILLER_0_38_190 vssd1 vssd1 vccd1 vccd1 sky130_fd_sc_hd__decap_6
X_2823_ _1275_ _1276_ _1278_ _1280_ vssd1 vssd1 vccd1 vccd1 _1281_ sky130_fd_sc_hd__o211ai_2
X_2754_ _1211_ u_core.u_regfile.rf\[28\]\[20\] _0696_ vssd1 vssd1 vccd1 vccd1 _1212_
+ sky130_fd_sc_hd__mux2_1
XFILLER_0_53_182 vssd1 vssd1 vccd1 vccd1 sky130_fd_sc_hd__decap_6
X_2685_ _0964_ _0963_ _0735_ _0957_ vssd1 vssd1 vccd1 vccd1 _1143_ sky130_fd_sc_hd__nand4_1
XFILLER_0_30_95 vssd1 vssd1 vccd1 vccd1 sky130_fd_sc_hd__fill_1
XFILLER_0_41_366 vccd1 vssd1 vccd1 vssd1 sky130_ef_sc_hd__decap_12
XFILLER_0_1_441 vssd1 vssd1 vccd1 vccd1 sky130_fd_sc_hd__decap_6
X_4424_ clknet_leaf_7_clk _0235_ vssd1 vssd1 vccd1 vccd1 u_core.u_regfile.rf\[29\]\[28\]
+ sky130_fd_sc_hd__dfxtp_1
XFILLER_0_1_485 vccd1 vssd1 vccd1 vssd1 sky130_ef_sc_hd__decap_12
X_4355_ clknet_leaf_18_clk _0166_ vssd1 vssd1 vccd1 vccd1 u_core.u_regfile.rf\[5\]\[23\]
+ sky130_fd_sc_hd__dfxtp_1
X_3306_ net472 vssd1 vssd1 vccd1 vccd1 _1644_ sky130_fd_sc_hd__clkbuf_1
XTAP_241 vssd1 vccd1 sky130_fd_sc_hd__tapvpwrvgnd_1
XTAP_230 vssd1 vccd1 sky130_fd_sc_hd__tapvpwrvgnd_1
XTAP_274 vssd1 vccd1 sky130_fd_sc_hd__tapvpwrvgnd_1
XTAP_263 vssd1 vccd1 sky130_fd_sc_hd__tapvpwrvgnd_1
XTAP_252 vssd1 vccd1 sky130_fd_sc_hd__tapvpwrvgnd_1
X_4286_ clknet_leaf_47_clk _0097_ vssd1 vssd1 vccd1 vccd1 u_core.u_regfile.rf\[6\]\[18\]
+ sky130_fd_sc_hd__dfxtp_1
XTAP_296 vssd1 vccd1 sky130_fd_sc_hd__tapvpwrvgnd_1
XTAP_285 vssd1 vccd1 sky130_fd_sc_hd__tapvpwrvgnd_1
X_3237_ u_core.u_regfile.rf\[31\]\[29\] vssd1 vssd1 vccd1 vccd1 _1620_ sky130_fd_sc_hd__clkbuf_1
X_3168_ u_audio.counter\[3\] u_audio.counter\[2\] u_audio.counter\[1\] net365 vssd1
+ vssd1 vccd1 vccd1 _1585_ sky130_fd_sc_hd__and4_2
X_2119_ u_timer.count_reg\[31\] _0576_ vssd1 vssd1 vccd1 vccd1 _0578_ sky130_fd_sc_hd__nor2_1
X_3099_ _0605_ _0606_ _0661_ _1533_ vssd1 vssd1 vccd1 vccd1 _1534_ sky130_fd_sc_hd__or4b_1
Xfanout23 net33 vssd1 vssd1 vccd1 vccd1 net23 sky130_fd_sc_hd__clkbuf_4
XFILLER_0_36_138 vssd1 vssd1 vccd1 vccd1 sky130_fd_sc_hd__fill_2
XFILLER_0_44_193 vssd1 vssd1 vccd1 vccd1 sky130_fd_sc_hd__decap_3
XFILLER_0_4_290 vccd1 vssd1 vccd1 vssd1 sky130_ef_sc_hd__decap_12
Xhold481 u_core.u_regfile.rf\[31\]\[2\] vssd1 vssd1 vccd1 vccd1 net514 sky130_fd_sc_hd__dlygate4sd3_1
Xhold470 u_audio.sample_reg\[7\] vssd1 vssd1 vccd1 vccd1 net503 sky130_fd_sc_hd__dlygate4sd3_1
Xhold492 u_core.u_regfile.rf\[28\]\[5\] vssd1 vssd1 vccd1 vccd1 net525 sky130_fd_sc_hd__dlygate4sd3_1
XFILLER_0_82_266 vssd1 vssd1 vccd1 vccd1 sky130_fd_sc_hd__fill_1
XFILLER_0_50_152 vssd1 vssd1 vccd1 vccd1 sky130_fd_sc_hd__decap_3
X_2470_ u_core.u_regfile.rf\[29\]\[15\] u_core.u_regfile.rf\[31\]\[15\] _0704_ vssd1
+ vssd1 vccd1 vccd1 _0928_ sky130_fd_sc_hd__mux2_1
XFILLER_0_50_185 vssd1 vssd1 vccd1 vccd1 sky130_fd_sc_hd__fill_1
X_4140_ _1737_ _1715_ _1706_ _1071_ vssd1 vssd1 vccd1 vccd1 _2069_ sky130_fd_sc_hd__nand4_1
X_4071_ _2031_ vssd1 vssd1 vccd1 vccd1 _0498_ sky130_fd_sc_hd__clkbuf_1
X_3022_ _1479_ vssd1 vssd1 vccd1 vccd1 _1480_ sky130_fd_sc_hd__clkbuf_4
XFILLER_0_25_51 vssd1 vssd1 vccd1 vccd1 sky130_fd_sc_hd__fill_1
X_3924_ net399 vssd1 vssd1 vccd1 vccd1 _1958_ sky130_fd_sc_hd__clkbuf_1
XFILLER_0_46_425 vssd1 vssd1 vccd1 vccd1 sky130_fd_sc_hd__fill_1
X_3855_ _1923_ vssd1 vssd1 vccd1 vccd1 _0390_ sky130_fd_sc_hd__clkbuf_1
XFILLER_0_33_108 vssd1 vssd1 vccd1 vccd1 sky130_fd_sc_hd__fill_1
X_2806_ _0758_ _0954_ u_core.u_regfile.rf\[28\]\[22\] vssd1 vssd1 vccd1 vccd1 _1264_
+ sky130_fd_sc_hd__o21a_1
X_3786_ _1674_ _1862_ net94 vssd1 vssd1 vccd1 vccd1 _1889_ sky130_fd_sc_hd__o21ai_1
X_2737_ _1193_ _0938_ _0802_ _1194_ _0700_ vssd1 vssd1 vccd1 vccd1 _1195_ sky130_fd_sc_hd__o2111ai_2
XFILLER_0_74_3 vccd1 vssd1 vccd1 vssd1 sky130_ef_sc_hd__decap_12
X_2668_ u_core.u_regfile.rf\[31\]\[13\] _0727_ _0746_ _0715_ vssd1 vssd1 vccd1 vccd1
+ _1126_ sky130_fd_sc_hd__o22a_1
X_4407_ clknet_leaf_31_clk _0218_ vssd1 vssd1 vccd1 vccd1 u_core.u_regfile.rf\[29\]\[11\]
+ sky130_fd_sc_hd__dfxtp_1
XFILLER_0_1_293 vccd1 vssd1 vccd1 vssd1 sky130_ef_sc_hd__decap_12
X_2599_ _1052_ _1056_ vssd1 vssd1 vccd1 vccd1 _1057_ sky130_fd_sc_hd__nor2_2
X_4338_ clknet_leaf_5_clk _0149_ vssd1 vssd1 vccd1 vccd1 u_core.u_regfile.rf\[5\]\[6\]
+ sky130_fd_sc_hd__dfxtp_1
X_4269_ clknet_leaf_48_clk _0080_ vssd1 vssd1 vccd1 vccd1 u_core.u_regfile.rf\[6\]\[1\]
+ sky130_fd_sc_hd__dfxtp_1
XFILLER_0_84_509 vssd1 vssd1 vccd1 vccd1 sky130_fd_sc_hd__fill_1
XFILLER_0_37_447 vssd1 vssd1 vccd1 vccd1 sky130_fd_sc_hd__fill_1
XFILLER_0_9_382 vssd1 vssd1 vccd1 vccd1 sky130_fd_sc_hd__decap_6
XFILLER_0_64_277 vccd1 vssd1 vccd1 vssd1 sky130_ef_sc_hd__decap_12
XFILLER_0_17_193 vssd1 vssd1 vccd1 vccd1 sky130_fd_sc_hd__decap_4
XFILLER_0_32_141 vssd1 vssd1 vccd1 vccd1 sky130_fd_sc_hd__decap_6
XFILLER_0_60_494 vccd1 vssd1 vccd1 vssd1 sky130_ef_sc_hd__decap_12
XFILLER_0_62_27 vssd1 vssd1 vccd1 vccd1 sky130_fd_sc_hd__fill_1
XFILLER_0_75_509 vssd1 vssd1 vccd1 vccd1 sky130_fd_sc_hd__fill_1
XFILLER_0_15_108 vssd1 vssd1 vccd1 vccd1 sky130_fd_sc_hd__decap_4
XFILLER_0_55_277 vssd1 vssd1 vccd1 vccd1 sky130_fd_sc_hd__decap_3
XFILLER_0_15_119 vssd1 vssd1 vccd1 vccd1 sky130_fd_sc_hd__decap_3
XFILLER_0_3_503 vssd1 vssd1 vccd1 vccd1 sky130_fd_sc_hd__fill_1
X_3640_ _1812_ vssd1 vssd1 vccd1 vccd1 _0286_ sky130_fd_sc_hd__clkbuf_1
X_3571_ _1632_ _1633_ _1790_ net54 vssd1 vssd1 vccd1 vccd1 _0239_ sky130_fd_sc_hd__o31a_1
X_2522_ _0951_ _0966_ _0967_ _0979_ vssd1 vssd1 vccd1 vccd1 _0980_ sky130_fd_sc_hd__o211ai_2
X_2453_ _0907_ _0908_ _0714_ _0909_ _0910_ vssd1 vssd1 vccd1 vccd1 _0911_ sky130_fd_sc_hd__o2111ai_4
X_2384_ _0841_ _0710_ _0714_ vssd1 vssd1 vccd1 vccd1 _0842_ sky130_fd_sc_hd__and3_1
X_4123_ _2057_ vssd1 vssd1 vccd1 vccd1 _0524_ sky130_fd_sc_hd__clkbuf_1
X_4054_ net296 vssd1 vssd1 vccd1 vccd1 _2023_ sky130_fd_sc_hd__clkbuf_1
X_3005_ _1003_ _1446_ _0919_ vssd1 vssd1 vccd1 vccd1 _1463_ sky130_fd_sc_hd__a21boi_1
XFILLER_0_36_83 vssd1 vssd1 vccd1 vccd1 sky130_fd_sc_hd__fill_1
XFILLER_0_66_509 vssd1 vssd1 vccd1 vccd1 sky130_fd_sc_hd__fill_1
XFILLER_0_52_82 vssd1 vssd1 vccd1 vccd1 sky130_fd_sc_hd__fill_2
X_3907_ _1949_ vssd1 vssd1 vccd1 vccd1 _0416_ sky130_fd_sc_hd__clkbuf_1
XFILLER_0_46_244 vssd1 vssd1 vccd1 vccd1 sky130_fd_sc_hd__decap_8
XFILLER_0_6_341 vssd1 vssd1 vccd1 vccd1 sky130_fd_sc_hd__fill_1
XFILLER_0_46_288 vccd1 vssd1 vccd1 vssd1 sky130_ef_sc_hd__decap_12
X_3838_ net298 vssd1 vssd1 vccd1 vccd1 _1915_ sky130_fd_sc_hd__clkbuf_1
XFILLER_0_6_363 vssd1 vssd1 vccd1 vccd1 sky130_fd_sc_hd__fill_1
X_3769_ _1861_ _1448_ _1880_ vssd1 vssd1 vccd1 vccd1 _0347_ sky130_fd_sc_hd__o21ai_1
XFILLER_0_57_509 vssd1 vssd1 vccd1 vccd1 sky130_fd_sc_hd__fill_1
XFILLER_0_77_391 vssd1 vssd1 vccd1 vccd1 sky130_fd_sc_hd__fill_1
XFILLER_0_80_501 vssd1 vssd1 vccd1 vccd1 sky130_fd_sc_hd__decap_8
XFILLER_0_37_244 vccd1 vssd1 vccd1 vssd1 sky130_ef_sc_hd__decap_12
XFILLER_0_52_236 vssd1 vssd1 vccd1 vccd1 sky130_fd_sc_hd__fill_1
XFILLER_0_20_111 vssd1 vssd1 vccd1 vccd1 sky130_fd_sc_hd__fill_2
XTAP_807 vssd1 vccd1 sky130_fd_sc_hd__tapvpwrvgnd_1
XTAP_829 vssd1 vccd1 sky130_fd_sc_hd__tapvpwrvgnd_1
XFILLER_0_57_27 vccd1 vssd1 vccd1 vssd1 sky130_ef_sc_hd__decap_12
XTAP_818 vssd1 vccd1 sky130_fd_sc_hd__tapvpwrvgnd_1
XFILLER_0_73_15 vccd1 vssd1 vccd1 vssd1 sky130_ef_sc_hd__decap_12
XFILLER_0_83_361 vccd1 vssd1 vccd1 vssd1 sky130_ef_sc_hd__decap_12
X_4741_ clknet_leaf_14_clk _0036_ net25 vssd1 vssd1 vccd1 vccd1 u_timer.count_reg\[7\]
+ sky130_fd_sc_hd__dfrtp_4
X_4672_ clknet_leaf_41_clk _0473_ vssd1 vssd1 vccd1 vccd1 u_core.u_regfile.rf\[24\]\[10\]
+ sky130_fd_sc_hd__dfxtp_1
XFILLER_0_22_85 vssd1 vssd1 vccd1 vccd1 sky130_fd_sc_hd__decap_4
XFILLER_0_28_288 vssd1 vssd1 vccd1 vccd1 sky130_fd_sc_hd__fill_2
XFILLER_0_43_225 vccd1 vssd1 vccd1 vssd1 sky130_ef_sc_hd__decap_12
XFILLER_0_31_409 vssd1 vssd1 vccd1 vccd1 sky130_fd_sc_hd__fill_1
X_3623_ net301 vssd1 vssd1 vccd1 vccd1 _1804_ sky130_fd_sc_hd__clkbuf_1
X_3554_ net424 vssd1 vssd1 vccd1 vccd1 _1782_ sky130_fd_sc_hd__clkbuf_1
X_3485_ _1731_ _1413_ _1739_ _1480_ _0601_ vssd1 vssd1 vccd1 vccd1 _1746_ sky130_fd_sc_hd__a41o_1
X_2505_ _0813_ _0960_ _0961_ _0962_ vssd1 vssd1 vccd1 vccd1 _0963_ sky130_fd_sc_hd__a31o_2
X_2436_ _0875_ _0892_ _0893_ vssd1 vssd1 vccd1 vccd1 _0894_ sky130_fd_sc_hd__o21ai_2
XFILLER_0_37_3 vssd1 vssd1 vccd1 vccd1 sky130_fd_sc_hd__decap_8
X_2367_ u_core.u_regfile.rf\[1\]\[25\] _0743_ _0759_ _0711_ vssd1 vssd1 vccd1 vccd1
+ _0825_ sky130_fd_sc_hd__o2bb2a_1
X_4106_ net361 vssd1 vssd1 vccd1 vccd1 _2049_ sky130_fd_sc_hd__clkbuf_1
X_2298_ _0755_ vssd1 vssd1 vccd1 vccd1 _0756_ sky130_fd_sc_hd__clkbuf_4
X_4037_ _2014_ vssd1 vssd1 vccd1 vccd1 _0481_ sky130_fd_sc_hd__clkbuf_1
XPHY_106 vssd1 vssd1 vccd1 vccd1 sky130_fd_sc_hd__decap_3
XFILLER_0_19_211 vssd1 vssd1 vccd1 vccd1 sky130_fd_sc_hd__fill_2
XFILLER_0_19_222 vssd1 vssd1 vccd1 vccd1 sky130_fd_sc_hd__fill_2
XPHY_117 vssd1 vssd1 vccd1 vccd1 sky130_fd_sc_hd__decap_3
XPHY_128 vssd1 vssd1 vccd1 vccd1 sky130_fd_sc_hd__decap_3
XPHY_139 vssd1 vssd1 vccd1 vccd1 sky130_fd_sc_hd__decap_3
XFILLER_0_34_214 vssd1 vssd1 vccd1 vccd1 sky130_fd_sc_hd__fill_2
Xmax_cap20 _0760_ vssd1 vssd1 vccd1 vccd1 net20 sky130_fd_sc_hd__clkbuf_2
XPHY_8 vssd1 vssd1 vccd1 vccd1 sky130_fd_sc_hd__decap_3
XFILLER_0_84_169 vssd1 vssd1 vccd1 vccd1 sky130_fd_sc_hd__fill_1
XFILLER_0_72_309 vccd1 vssd1 vccd1 vssd1 sky130_ef_sc_hd__decap_12
XFILLER_0_13_409 vssd1 vssd1 vccd1 vccd1 sky130_fd_sc_hd__fill_1
XFILLER_0_21_420 vssd1 vssd1 vccd1 vccd1 sky130_fd_sc_hd__fill_1
XFILLER_0_68_15 vccd1 vssd1 vccd1 vssd1 sky130_ef_sc_hd__decap_12
XFILLER_0_0_369 vssd1 vssd1 vccd1 vccd1 sky130_fd_sc_hd__fill_1
X_3270_ _1486_ vssd1 vssd1 vccd1 vccd1 _1630_ sky130_fd_sc_hd__clkbuf_4
XTAP_604 vssd1 vccd1 sky130_fd_sc_hd__tapvpwrvgnd_1
XTAP_615 vssd1 vccd1 sky130_fd_sc_hd__tapvpwrvgnd_1
X_2221_ _0598_ _0586_ vssd1 vssd1 vccd1 vccd1 _0680_ sky130_fd_sc_hd__nand2_1
XTAP_626 vssd1 vccd1 sky130_fd_sc_hd__tapvpwrvgnd_1
XTAP_637 vssd1 vccd1 sky130_fd_sc_hd__tapvpwrvgnd_1
XTAP_648 vssd1 vccd1 sky130_fd_sc_hd__tapvpwrvgnd_1
XTAP_659 vssd1 vccd1 sky130_fd_sc_hd__tapvpwrvgnd_1
X_2152_ u_timer.count_reg\[22\] _0600_ _0610_ _0602_ vssd1 vssd1 vccd1 vccd1 _0611_
+ sky130_fd_sc_hd__o211a_1
XFILLER_0_8_403 vssd1 vssd1 vccd1 vccd1 sky130_fd_sc_hd__fill_2
XFILLER_0_63_309 vccd1 vssd1 vccd1 vssd1 sky130_ef_sc_hd__decap_12
X_4724_ clknet_leaf_49_clk _0525_ vssd1 vssd1 vccd1 vccd1 u_core.u_regfile.rf\[25\]\[30\]
+ sky130_fd_sc_hd__dfxtp_1
X_2985_ _1440_ _1442_ vssd1 vssd1 vccd1 vccd1 _1443_ sky130_fd_sc_hd__nand2_1
X_4655_ clknet_leaf_35_clk _0456_ vssd1 vssd1 vccd1 vccd1 u_core.u_regfile.rf\[26\]\[25\]
+ sky130_fd_sc_hd__dfxtp_1
X_4586_ clknet_leaf_37_clk _0387_ vssd1 vssd1 vccd1 vccd1 u_core.u_regfile.rf\[27\]\[20\]
+ sky130_fd_sc_hd__dfxtp_1
XFILLER_0_31_228 vssd1 vssd1 vccd1 vccd1 sky130_fd_sc_hd__fill_1
X_3606_ _1487_ _1486_ _1796_ net97 vssd1 vssd1 vccd1 vccd1 _0268_ sky130_fd_sc_hd__o31a_1
X_3537_ _1773_ vssd1 vssd1 vccd1 vccd1 _0222_ sky130_fd_sc_hd__clkbuf_1
XFILLER_0_12_475 vssd1 vssd1 vccd1 vccd1 sky130_fd_sc_hd__fill_1
XFILLER_0_58_70 vssd1 vssd1 vccd1 vccd1 sky130_fd_sc_hd__decap_3
X_3468_ _1350_ _1704_ _1734_ vssd1 vssd1 vccd1 vccd1 _0192_ sky130_fd_sc_hd__o21ai_1
X_2419_ _0730_ _0695_ _0720_ vssd1 vssd1 vccd1 vccd1 _0877_ sky130_fd_sc_hd__and3_1
X_3399_ _1332_ vssd1 vssd1 vccd1 vccd1 _1683_ sky130_fd_sc_hd__buf_2
XFILLER_0_35_501 vssd1 vssd1 vccd1 vccd1 sky130_fd_sc_hd__decap_3
XFILLER_0_62_320 vssd1 vssd1 vccd1 vccd1 sky130_fd_sc_hd__decap_6
XFILLER_0_38_29 vssd1 vssd1 vccd1 vccd1 sky130_fd_sc_hd__decap_8
XFILLER_0_57_169 vssd1 vssd1 vccd1 vccd1 sky130_fd_sc_hd__fill_1
XFILLER_0_70_27 vssd1 vssd1 vccd1 vccd1 sky130_fd_sc_hd__fill_1
XFILLER_0_85_489 vccd1 vssd1 vccd1 vssd1 sky130_ef_sc_hd__decap_12
X_2770_ _1226_ _1227_ _0751_ vssd1 vssd1 vccd1 vccd1 _1228_ sky130_fd_sc_hd__nand3b_2
XFILLER_0_53_364 vssd1 vssd1 vccd1 vccd1 sky130_fd_sc_hd__decap_8
XFILLER_0_79_69 vccd1 vssd1 vccd1 vssd1 sky130_ef_sc_hd__decap_12
X_4440_ clknet_leaf_50_clk _0241_ vssd1 vssd1 vccd1 vccd1 u_core.u_regfile.rf\[7\]\[2\]
+ sky130_fd_sc_hd__dfxtp_1
Xhold107 u_core.u_regfile.rf\[2\]\[21\] vssd1 vssd1 vccd1 vccd1 net140 sky130_fd_sc_hd__dlygate4sd3_1
Xhold129 u_core.u_regfile.rf\[30\]\[16\] vssd1 vssd1 vccd1 vccd1 net162 sky130_fd_sc_hd__dlygate4sd3_1
Xhold118 u_core.u_regfile.rf\[3\]\[8\] vssd1 vssd1 vccd1 vccd1 net151 sky130_fd_sc_hd__dlygate4sd3_1
X_4371_ clknet_leaf_13_clk _0182_ net24 vssd1 vssd1 vccd1 vccd1 u_timer.threshold_reg\[7\]
+ sky130_fd_sc_hd__dfrtp_1
XFILLER_0_0_177 vssd1 vssd1 vccd1 vccd1 sky130_fd_sc_hd__fill_1
X_3322_ net420 vssd1 vssd1 vccd1 vccd1 _1652_ sky130_fd_sc_hd__clkbuf_1
XTAP_401 vssd1 vccd1 sky130_fd_sc_hd__tapvpwrvgnd_1
XTAP_412 vssd1 vccd1 sky130_fd_sc_hd__tapvpwrvgnd_1
XTAP_423 vssd1 vccd1 sky130_fd_sc_hd__tapvpwrvgnd_1
X_3253_ _1623_ _1624_ _1625_ net120 vssd1 vssd1 vccd1 vccd1 _0086_ sky130_fd_sc_hd__o31a_1
XTAP_434 vssd1 vccd1 sky130_fd_sc_hd__tapvpwrvgnd_1
XTAP_445 vssd1 vccd1 sky130_fd_sc_hd__tapvpwrvgnd_1
XTAP_456 vssd1 vccd1 sky130_fd_sc_hd__tapvpwrvgnd_1
XTAP_467 vssd1 vccd1 sky130_fd_sc_hd__tapvpwrvgnd_1
X_2204_ u_timer.count_reg\[20\] vssd1 vssd1 vccd1 vccd1 _0663_ sky130_fd_sc_hd__inv_2
XFILLER_0_28_62 vssd1 vssd1 vccd1 vccd1 sky130_fd_sc_hd__decap_6
XTAP_478 vssd1 vccd1 sky130_fd_sc_hd__tapvpwrvgnd_1
XTAP_489 vssd1 vccd1 sky130_fd_sc_hd__tapvpwrvgnd_1
X_3184_ _1593_ vssd1 vssd1 vccd1 vccd1 _0049_ sky130_fd_sc_hd__clkbuf_1
X_2135_ _0590_ _0593_ vssd1 vssd1 vccd1 vccd1 _0594_ sky130_fd_sc_hd__nand2_1
XFILLER_0_76_489 vccd1 vssd1 vccd1 vssd1 sky130_ef_sc_hd__decap_12
X_2968_ _1041_ _0772_ _0707_ _1047_ vssd1 vssd1 vccd1 vccd1 _1426_ sky130_fd_sc_hd__a31o_1
XFILLER_0_71_150 vccd1 vssd1 vccd1 vssd1 sky130_ef_sc_hd__decap_12
X_4707_ clknet_leaf_32_clk _0508_ vssd1 vssd1 vccd1 vccd1 u_core.u_regfile.rf\[25\]\[13\]
+ sky130_fd_sc_hd__dfxtp_1
X_4638_ clknet_leaf_33_clk _0439_ vssd1 vssd1 vccd1 vccd1 u_core.u_regfile.rf\[26\]\[8\]
+ sky130_fd_sc_hd__dfxtp_1
X_2899_ _1206_ _1354_ _1192_ vssd1 vssd1 vccd1 vccd1 _1357_ sky130_fd_sc_hd__o21a_1
XFILLER_0_8_83 vssd1 vssd1 vccd1 vccd1 sky130_fd_sc_hd__fill_1
X_4569_ clknet_leaf_34_clk _0370_ vssd1 vssd1 vccd1 vccd1 u_core.u_regfile.rf\[27\]\[3\]
+ sky130_fd_sc_hd__dfxtp_1
XFILLER_0_39_169 vccd1 vssd1 vccd1 vssd1 sky130_ef_sc_hd__decap_12
XFILLER_0_54_128 vssd1 vssd1 vccd1 vccd1 sky130_fd_sc_hd__decap_3
XFILLER_0_35_331 vssd1 vssd1 vccd1 vccd1 sky130_fd_sc_hd__decap_4
XFILLER_0_62_194 vssd1 vssd1 vccd1 vccd1 sky130_fd_sc_hd__fill_2
XFILLER_0_49_39 vssd1 vssd1 vccd1 vccd1 sky130_fd_sc_hd__fill_1
XFILLER_0_50_389 vssd1 vssd1 vccd1 vccd1 sky130_fd_sc_hd__fill_2
XFILLER_0_81_15 vccd1 vssd1 vccd1 vssd1 sky130_ef_sc_hd__decap_12
X_3940_ net266 vssd1 vssd1 vccd1 vccd1 _1966_ sky130_fd_sc_hd__clkbuf_1
XFILLER_0_85_253 vccd1 vssd1 vccd1 vssd1 sky130_ef_sc_hd__decap_12
XFILLER_0_18_309 vssd1 vssd1 vccd1 vccd1 sky130_fd_sc_hd__decap_3
X_3871_ _1931_ vssd1 vssd1 vccd1 vccd1 _0398_ sky130_fd_sc_hd__clkbuf_1
XFILLER_0_73_437 vssd1 vssd1 vccd1 vccd1 sky130_fd_sc_hd__decap_8
X_2822_ _1235_ _0780_ _1279_ vssd1 vssd1 vccd1 vccd1 _1280_ sky130_fd_sc_hd__or3_1
X_2753_ u_core.u_regfile.rf\[29\]\[20\] u_core.u_regfile.rf\[31\]\[20\] _0840_ vssd1
+ vssd1 vccd1 vccd1 _1211_ sky130_fd_sc_hd__mux2_1
XFILLER_0_26_397 vssd1 vssd1 vccd1 vccd1 sky130_fd_sc_hd__decap_6
XFILLER_0_41_312 vssd1 vssd1 vccd1 vccd1 sky130_fd_sc_hd__decap_3
X_2684_ _1132_ _0781_ _1136_ _1141_ vssd1 vssd1 vccd1 vccd1 _1142_ sky130_fd_sc_hd__o31a_1
XFILLER_0_41_378 vssd1 vssd1 vccd1 vccd1 sky130_fd_sc_hd__fill_1
X_4423_ clknet_leaf_6_clk _0234_ vssd1 vssd1 vccd1 vccd1 u_core.u_regfile.rf\[29\]\[27\]
+ sky130_fd_sc_hd__dfxtp_1
X_4354_ clknet_leaf_18_clk _0165_ vssd1 vssd1 vccd1 vccd1 u_core.u_regfile.rf\[5\]\[22\]
+ sky130_fd_sc_hd__dfxtp_1
X_3305_ _1643_ vssd1 vssd1 vccd1 vccd1 _0120_ sky130_fd_sc_hd__clkbuf_1
XTAP_242 vssd1 vccd1 sky130_fd_sc_hd__tapvpwrvgnd_1
XTAP_231 vssd1 vccd1 sky130_fd_sc_hd__tapvpwrvgnd_1
XFILLER_0_1_497 vssd1 vssd1 vccd1 vccd1 sky130_fd_sc_hd__decap_6
XTAP_220 vssd1 vccd1 sky130_fd_sc_hd__tapvpwrvgnd_1
XTAP_275 vssd1 vccd1 sky130_fd_sc_hd__tapvpwrvgnd_1
XTAP_264 vssd1 vccd1 sky130_fd_sc_hd__tapvpwrvgnd_1
X_4285_ clknet_leaf_49_clk _0096_ vssd1 vssd1 vccd1 vccd1 u_core.u_regfile.rf\[6\]\[17\]
+ sky130_fd_sc_hd__dfxtp_1
XTAP_253 vssd1 vccd1 sky130_fd_sc_hd__tapvpwrvgnd_1
XTAP_297 vssd1 vccd1 sky130_fd_sc_hd__tapvpwrvgnd_1
XTAP_286 vssd1 vccd1 sky130_fd_sc_hd__tapvpwrvgnd_1
X_3236_ _1619_ vssd1 vssd1 vccd1 vccd1 _0075_ sky130_fd_sc_hd__clkbuf_1
X_3167_ _1583_ _1584_ vssd1 vssd1 vccd1 vccd1 _0041_ sky130_fd_sc_hd__nor2_1
X_3098_ u_timer.count_reg\[15\] u_timer.count_reg\[14\] u_timer.count_reg\[13\] _1519_
+ vssd1 vssd1 vccd1 vccd1 _1533_ sky130_fd_sc_hd__and4_1
X_2118_ _0575_ u_timer.count_reg\[30\] _0576_ u_timer.count_reg\[31\] vssd1 vssd1
+ vccd1 vccd1 _0577_ sky130_fd_sc_hd__a22oi_1
Xfanout24 net26 vssd1 vssd1 vccd1 vccd1 net24 sky130_fd_sc_hd__clkbuf_4
XFILLER_0_71_81 vccd1 vssd1 vccd1 vssd1 sky130_ef_sc_hd__decap_12
XFILLER_0_64_437 vssd1 vssd1 vccd1 vccd1 sky130_fd_sc_hd__fill_2
XFILLER_0_44_172 vssd1 vssd1 vccd1 vccd1 sky130_fd_sc_hd__fill_1
XFILLER_0_32_345 vssd1 vssd1 vccd1 vccd1 sky130_fd_sc_hd__decap_4
Xhold471 u_core.u_regfile.rf\[28\]\[8\] vssd1 vssd1 vccd1 vccd1 net504 sky130_fd_sc_hd__dlygate4sd3_1
Xhold460 u_audio.sample_reg\[2\] vssd1 vssd1 vccd1 vccd1 net493 sky130_fd_sc_hd__dlygate4sd3_1
Xhold482 u_audio.counter\[6\] vssd1 vssd1 vccd1 vccd1 net515 sky130_fd_sc_hd__dlygate4sd3_1
Xhold493 net4 vssd1 vssd1 vccd1 vccd1 net526 sky130_fd_sc_hd__dlygate4sd3_1
XFILLER_0_63_481 vssd1 vssd1 vccd1 vccd1 sky130_fd_sc_hd__decap_4
XFILLER_0_76_15 vccd1 vssd1 vccd1 vssd1 sky130_ef_sc_hd__decap_12
XFILLER_0_50_197 vssd1 vssd1 vccd1 vccd1 sky130_fd_sc_hd__decap_6
X_4070_ net284 vssd1 vssd1 vccd1 vccd1 _2031_ sky130_fd_sc_hd__clkbuf_1
X_3021_ _0768_ _1477_ _1478_ vssd1 vssd1 vccd1 vccd1 _1479_ sky130_fd_sc_hd__o21ai_2
X_3923_ _1957_ vssd1 vssd1 vccd1 vccd1 _0424_ sky130_fd_sc_hd__clkbuf_1
XFILLER_0_73_223 vssd1 vssd1 vccd1 vccd1 sky130_fd_sc_hd__fill_1
X_3854_ net215 vssd1 vssd1 vccd1 vccd1 _1923_ sky130_fd_sc_hd__clkbuf_1
XFILLER_0_73_267 vssd1 vssd1 vccd1 vccd1 sky130_fd_sc_hd__decap_8
X_2805_ u_core.u_regfile.rf\[29\]\[22\] u_core.u_regfile.rf\[31\]\[22\] _0705_ vssd1
+ vssd1 vccd1 vccd1 _1263_ sky130_fd_sc_hd__mux2_1
X_3785_ _1390_ _1875_ _1363_ _1888_ vssd1 vssd1 vccd1 vccd1 _0355_ sky130_fd_sc_hd__a31o_1
X_2736_ _0753_ u_core.u_regfile.rf\[7\]\[17\] _0713_ vssd1 vssd1 vccd1 vccd1 _1194_
+ sky130_fd_sc_hd__nand3_1
X_2667_ _0813_ _1122_ _1123_ _1124_ vssd1 vssd1 vccd1 vccd1 _1125_ sky130_fd_sc_hd__a31o_1
XFILLER_0_1_261 vccd1 vssd1 vccd1 vssd1 sky130_ef_sc_hd__decap_12
X_4406_ clknet_leaf_42_clk _0217_ vssd1 vssd1 vccd1 vccd1 u_core.u_regfile.rf\[29\]\[10\]
+ sky130_fd_sc_hd__dfxtp_1
XFILLER_0_67_3 vccd1 vssd1 vccd1 vssd1 sky130_ef_sc_hd__decap_12
X_2598_ _1053_ _1054_ _0749_ _1055_ vssd1 vssd1 vccd1 vccd1 _1056_ sky130_fd_sc_hd__a31oi_4
X_4337_ clknet_leaf_6_clk _0148_ vssd1 vssd1 vccd1 vccd1 u_core.u_regfile.rf\[5\]\[5\]
+ sky130_fd_sc_hd__dfxtp_1
X_4268_ clknet_leaf_49_clk _0079_ vssd1 vssd1 vccd1 vccd1 u_core.u_regfile.rf\[6\]\[0\]
+ sky130_fd_sc_hd__dfxtp_1
XFILLER_0_66_70 vssd1 vssd1 vccd1 vccd1 sky130_fd_sc_hd__decap_3
X_3219_ u_core.u_regfile.rf\[31\]\[20\] vssd1 vssd1 vccd1 vccd1 _1611_ sky130_fd_sc_hd__clkbuf_1
X_4199_ _2099_ vssd1 vssd1 vccd1 vccd1 _0558_ sky130_fd_sc_hd__clkbuf_1
XFILLER_0_49_231 vssd1 vssd1 vccd1 vccd1 sky130_fd_sc_hd__decap_4
XFILLER_0_37_437 vssd1 vssd1 vccd1 vccd1 sky130_fd_sc_hd__fill_2
XFILLER_0_64_289 vccd1 vssd1 vccd1 vssd1 sky130_ef_sc_hd__decap_12
Xhold290 u_core.u_regfile.rf\[26\]\[1\] vssd1 vssd1 vccd1 vccd1 net323 sky130_fd_sc_hd__dlygate4sd3_1
XFILLER_0_46_29 vssd1 vssd1 vccd1 vccd1 sky130_fd_sc_hd__decap_8
XFILLER_0_7_309 vssd1 vssd1 vccd1 vccd1 sky130_fd_sc_hd__fill_1
XFILLER_0_28_437 vssd1 vssd1 vccd1 vccd1 sky130_fd_sc_hd__fill_2
XFILLER_0_55_223 vssd1 vssd1 vccd1 vccd1 sky130_fd_sc_hd__fill_1
XFILLER_0_55_267 vssd1 vssd1 vccd1 vccd1 sky130_fd_sc_hd__decap_4
XFILLER_0_11_65 vssd1 vssd1 vccd1 vccd1 sky130_fd_sc_hd__decap_6
X_3570_ _0778_ vssd1 vssd1 vccd1 vccd1 _1790_ sky130_fd_sc_hd__clkbuf_4
X_2521_ _0974_ _0965_ _0978_ vssd1 vssd1 vccd1 vccd1 _0979_ sky130_fd_sc_hd__nand3b_4
XFILLER_0_51_473 vssd1 vssd1 vccd1 vccd1 sky130_fd_sc_hd__fill_1
XFILLER_0_23_197 vssd1 vssd1 vccd1 vccd1 sky130_fd_sc_hd__fill_1
XFILLER_0_51_495 vssd1 vssd1 vccd1 vccd1 sky130_fd_sc_hd__fill_1
X_2452_ u_core.u_regfile.rf\[7\]\[13\] _0907_ vssd1 vssd1 vccd1 vccd1 _0910_ sky130_fd_sc_hd__nand2_1
X_2383_ u_core.u_regfile.rf\[29\]\[24\] u_core.u_regfile.rf\[31\]\[24\] _0840_ vssd1
+ vssd1 vccd1 vccd1 _0841_ sky130_fd_sc_hd__mux2_1
X_4122_ net212 vssd1 vssd1 vccd1 vccd1 _2057_ sky130_fd_sc_hd__clkbuf_1
X_4053_ _2022_ vssd1 vssd1 vccd1 vccd1 _0489_ sky130_fd_sc_hd__clkbuf_1
X_3004_ _1458_ _1461_ vssd1 vssd1 vccd1 vccd1 _1462_ sky130_fd_sc_hd__nand2_1
X_3906_ net455 vssd1 vssd1 vccd1 vccd1 _1949_ sky130_fd_sc_hd__clkbuf_1
XFILLER_0_46_267 vccd1 vssd1 vccd1 vssd1 sky130_ef_sc_hd__decap_12
X_3837_ _1914_ vssd1 vssd1 vccd1 vccd1 _0381_ sky130_fd_sc_hd__clkbuf_1
X_3768_ _1674_ _1862_ net42 vssd1 vssd1 vccd1 vccd1 _1880_ sky130_fd_sc_hd__o21ai_1
X_2719_ _0771_ _0773_ _0879_ u_core.u_regfile.rf\[5\]\[16\] _1176_ vssd1 vssd1 vccd1
+ vccd1 _1177_ sky130_fd_sc_hd__o221a_2
X_3699_ net348 vssd1 vssd1 vccd1 vccd1 _1842_ sky130_fd_sc_hd__clkbuf_1
XFILLER_0_69_326 vssd1 vssd1 vccd1 vccd1 sky130_fd_sc_hd__fill_2
XFILLER_0_37_201 vccd1 vssd1 vccd1 vssd1 sky130_ef_sc_hd__decap_12
XFILLER_0_37_256 vssd1 vssd1 vccd1 vccd1 sky130_fd_sc_hd__decap_3
XFILLER_0_33_495 vssd1 vssd1 vccd1 vccd1 sky130_fd_sc_hd__fill_1
XTAP_808 vssd1 vccd1 sky130_fd_sc_hd__tapvpwrvgnd_1
XFILLER_0_20_189 vssd1 vssd1 vccd1 vccd1 sky130_fd_sc_hd__fill_1
XFILLER_0_57_39 vccd1 vssd1 vccd1 vssd1 sky130_ef_sc_hd__decap_12
XTAP_819 vssd1 vccd1 sky130_fd_sc_hd__tapvpwrvgnd_1
XFILLER_0_73_27 vccd1 vssd1 vccd1 vssd1 sky130_ef_sc_hd__decap_12
XFILLER_0_75_318 vssd1 vssd1 vccd1 vccd1 sky130_fd_sc_hd__decap_8
X_4740_ clknet_leaf_13_clk _0035_ net25 vssd1 vssd1 vccd1 vccd1 u_timer.count_reg\[6\]
+ sky130_fd_sc_hd__dfrtp_2
XFILLER_0_7_106 vssd1 vssd1 vccd1 vccd1 sky130_fd_sc_hd__fill_2
XFILLER_0_28_245 vssd1 vssd1 vccd1 vccd1 sky130_fd_sc_hd__decap_4
XFILLER_0_83_373 vccd1 vssd1 vccd1 vssd1 sky130_ef_sc_hd__decap_12
XFILLER_0_71_502 vssd1 vssd1 vccd1 vccd1 sky130_fd_sc_hd__fill_2
X_4671_ clknet_leaf_39_clk _0472_ vssd1 vssd1 vccd1 vccd1 u_core.u_regfile.rf\[24\]\[9\]
+ sky130_fd_sc_hd__dfxtp_1
X_3622_ _1803_ vssd1 vssd1 vccd1 vccd1 _0277_ sky130_fd_sc_hd__clkbuf_1
XFILLER_0_43_237 vssd1 vssd1 vccd1 vccd1 sky130_fd_sc_hd__decap_6
X_3553_ _1781_ vssd1 vssd1 vccd1 vccd1 _0230_ sky130_fd_sc_hd__clkbuf_1
X_2504_ _0913_ u_core.u_regfile.rf\[1\]\[8\] _0858_ _0867_ vssd1 vssd1 vccd1 vccd1
+ _0962_ sky130_fd_sc_hd__a31o_1
X_3484_ _1277_ _1741_ _1745_ vssd1 vssd1 vccd1 vccd1 _0197_ sky130_fd_sc_hd__o21ai_1
X_2435_ _0715_ _0891_ _0711_ _0706_ _0884_ vssd1 vssd1 vccd1 vccd1 _0893_ sky130_fd_sc_hd__a41o_1
X_4105_ _2048_ vssd1 vssd1 vccd1 vccd1 _0515_ sky130_fd_sc_hd__clkbuf_1
X_2366_ u_core.u_regfile.rf\[4\]\[25\] _0756_ _0823_ vssd1 vssd1 vccd1 vccd1 _0824_
+ sky130_fd_sc_hd__a21oi_1
X_2297_ _0721_ _0695_ _0730_ vssd1 vssd1 vccd1 vccd1 _0755_ sky130_fd_sc_hd__a21o_1
XFILLER_0_2_41 vccd1 vssd1 vccd1 vssd1 sky130_ef_sc_hd__decap_12
X_4036_ net333 vssd1 vssd1 vccd1 vccd1 _2014_ sky130_fd_sc_hd__clkbuf_1
XFILLER_0_2_85 vssd1 vssd1 vccd1 vccd1 sky130_fd_sc_hd__decap_6
XPHY_107 vssd1 vssd1 vccd1 vccd1 sky130_fd_sc_hd__decap_3
XPHY_118 vssd1 vssd1 vccd1 vccd1 sky130_fd_sc_hd__decap_3
XPHY_129 vssd1 vssd1 vccd1 vccd1 sky130_fd_sc_hd__decap_3
XFILLER_0_19_267 vssd1 vssd1 vccd1 vccd1 sky130_fd_sc_hd__fill_2
XFILLER_0_34_237 vssd1 vssd1 vccd1 vccd1 sky130_fd_sc_hd__decap_6
XFILLER_0_15_484 vssd1 vssd1 vccd1 vccd1 sky130_fd_sc_hd__fill_1
XPHY_9 vssd1 vssd1 vccd1 vccd1 sky130_fd_sc_hd__decap_3
XFILLER_0_69_167 vssd1 vssd1 vccd1 vccd1 sky130_fd_sc_hd__fill_1
XFILLER_0_84_137 vssd1 vssd1 vccd1 vccd1 sky130_fd_sc_hd__decap_3
XFILLER_0_84_115 vssd1 vssd1 vccd1 vccd1 sky130_fd_sc_hd__fill_1
XFILLER_0_25_215 vssd1 vssd1 vccd1 vccd1 sky130_fd_sc_hd__fill_1
XFILLER_0_80_365 vssd1 vssd1 vccd1 vccd1 sky130_fd_sc_hd__decap_6
XFILLER_0_40_218 vssd1 vssd1 vccd1 vccd1 sky130_fd_sc_hd__fill_2
XFILLER_0_80_387 vssd1 vssd1 vccd1 vccd1 sky130_fd_sc_hd__fill_1
XFILLER_0_33_281 vssd1 vssd1 vccd1 vccd1 sky130_fd_sc_hd__fill_1
XFILLER_0_0_337 vccd1 vssd1 vccd1 vssd1 sky130_ef_sc_hd__decap_12
XFILLER_0_68_27 vssd1 vssd1 vccd1 vccd1 sky130_fd_sc_hd__fill_1
XTAP_605 vssd1 vccd1 sky130_fd_sc_hd__tapvpwrvgnd_1
XTAP_616 vssd1 vccd1 sky130_fd_sc_hd__tapvpwrvgnd_1
X_2220_ _0678_ _0611_ _0668_ _0601_ u_timer.count_reg\[23\] vssd1 vssd1 vccd1 vccd1
+ _0679_ sky130_fd_sc_hd__a32o_1
XTAP_627 vssd1 vccd1 sky130_fd_sc_hd__tapvpwrvgnd_1
XTAP_638 vssd1 vccd1 sky130_fd_sc_hd__tapvpwrvgnd_1
XTAP_649 vssd1 vccd1 sky130_fd_sc_hd__tapvpwrvgnd_1
XFILLER_0_84_15 vccd1 vssd1 vccd1 vssd1 sky130_ef_sc_hd__decap_12
X_2151_ _0600_ u_timer.count_reg\[22\] _0601_ u_timer.count_reg\[23\] vssd1 vssd1
+ vccd1 vccd1 _0610_ sky130_fd_sc_hd__a22oi_1
XFILLER_0_75_126 vccd1 vssd1 vccd1 vssd1 sky130_ef_sc_hd__decap_12
XFILLER_0_33_30 vssd1 vssd1 vccd1 vccd1 sky130_fd_sc_hd__fill_2
X_2984_ net18 _1441_ _1129_ vssd1 vssd1 vccd1 vccd1 _1442_ sky130_fd_sc_hd__o21ai_1
X_4723_ clknet_leaf_36_clk _0524_ vssd1 vssd1 vccd1 vccd1 u_core.u_regfile.rf\[25\]\[29\]
+ sky130_fd_sc_hd__dfxtp_1
XFILLER_0_83_181 vssd1 vssd1 vccd1 vccd1 sky130_fd_sc_hd__decap_8
X_4654_ clknet_leaf_19_clk _0455_ vssd1 vssd1 vccd1 vccd1 u_core.u_regfile.rf\[26\]\[24\]
+ sky130_fd_sc_hd__dfxtp_1
X_4585_ clknet_leaf_38_clk _0386_ vssd1 vssd1 vccd1 vccd1 u_core.u_regfile.rf\[27\]\[19\]
+ sky130_fd_sc_hd__dfxtp_1
XFILLER_0_24_270 vccd1 vssd1 vccd1 vssd1 sky130_ef_sc_hd__decap_12
X_3605_ _1487_ _1486_ _1796_ net88 vssd1 vssd1 vccd1 vccd1 _0267_ sky130_fd_sc_hd__o31a_1
X_3536_ net368 vssd1 vssd1 vccd1 vccd1 _1773_ sky130_fd_sc_hd__clkbuf_1
X_3467_ _1731_ _1725_ _1714_ _1726_ _1733_ vssd1 vssd1 vccd1 vccd1 _1734_ sky130_fd_sc_hd__a41o_1
X_2418_ _0732_ vssd1 vssd1 vccd1 vccd1 _0876_ sky130_fd_sc_hd__buf_4
X_3398_ _1023_ _1026_ _1027_ vssd1 vssd1 vccd1 vccd1 _1682_ sky130_fd_sc_hd__o21a_1
X_2349_ _0800_ _0781_ _0806_ vssd1 vssd1 vccd1 vccd1 _0807_ sky130_fd_sc_hd__or3b_1
X_4019_ _2005_ vssd1 vssd1 vccd1 vccd1 _0472_ sky130_fd_sc_hd__clkbuf_1
XFILLER_0_66_137 vssd1 vssd1 vccd1 vccd1 sky130_fd_sc_hd__decap_3
XFILLER_0_54_29 vccd1 vssd1 vccd1 vssd1 sky130_ef_sc_hd__decap_12
XFILLER_0_38_351 vssd1 vssd1 vccd1 vccd1 sky130_fd_sc_hd__decap_6
XFILLER_0_79_15 vccd1 vssd1 vccd1 vssd1 sky130_ef_sc_hd__decap_12
Xhold108 u_core.u_regfile.rf\[24\]\[9\] vssd1 vssd1 vccd1 vccd1 net141 sky130_fd_sc_hd__dlygate4sd3_1
Xhold119 u_core.u_regfile.rf\[30\]\[12\] vssd1 vssd1 vccd1 vccd1 net152 sky130_fd_sc_hd__dlygate4sd3_1
X_4370_ clknet_leaf_13_clk _0181_ net24 vssd1 vssd1 vccd1 vccd1 u_timer.threshold_reg\[6\]
+ sky130_fd_sc_hd__dfstp_1
X_3321_ _1651_ vssd1 vssd1 vccd1 vccd1 _0128_ sky130_fd_sc_hd__clkbuf_1
XTAP_402 vssd1 vccd1 sky130_fd_sc_hd__tapvpwrvgnd_1
XTAP_413 vssd1 vccd1 sky130_fd_sc_hd__tapvpwrvgnd_1
XTAP_424 vssd1 vccd1 sky130_fd_sc_hd__tapvpwrvgnd_1
X_3252_ _1623_ _1624_ _1625_ net124 vssd1 vssd1 vccd1 vccd1 _0085_ sky130_fd_sc_hd__o31a_1
XTAP_435 vssd1 vccd1 sky130_fd_sc_hd__tapvpwrvgnd_1
XTAP_446 vssd1 vccd1 sky130_fd_sc_hd__tapvpwrvgnd_1
XTAP_457 vssd1 vccd1 sky130_fd_sc_hd__tapvpwrvgnd_1
X_2203_ u_timer.threshold_reg\[16\] _0661_ u_timer.threshold_reg\[17\] _0606_ vssd1
+ vssd1 vccd1 vccd1 _0662_ sky130_fd_sc_hd__o22a_1
XTAP_468 vssd1 vccd1 sky130_fd_sc_hd__tapvpwrvgnd_1
XTAP_479 vssd1 vccd1 sky130_fd_sc_hd__tapvpwrvgnd_1
X_3183_ net514 vssd1 vssd1 vccd1 vccd1 _1593_ sky130_fd_sc_hd__clkbuf_1
X_2134_ u_timer.threshold_reg\[26\] _0591_ u_timer.threshold_reg\[27\] _0592_ vssd1
+ vssd1 vccd1 vccd1 _0593_ sky130_fd_sc_hd__o22a_1
XFILLER_0_28_85 vssd1 vssd1 vccd1 vccd1 sky130_fd_sc_hd__decap_4
XFILLER_0_76_468 vssd1 vssd1 vccd1 vccd1 sky130_fd_sc_hd__decap_8
XFILLER_0_8_201 vssd1 vssd1 vccd1 vccd1 sky130_fd_sc_hd__fill_1
X_2967_ _1028_ _0772_ _0707_ vssd1 vssd1 vccd1 vccd1 _1425_ sky130_fd_sc_hd__and3_1
X_4706_ clknet_leaf_33_clk _0507_ vssd1 vssd1 vccd1 vccd1 u_core.u_regfile.rf\[25\]\[12\]
+ sky130_fd_sc_hd__dfxtp_1
X_2898_ _1163_ _1165_ _1355_ vssd1 vssd1 vccd1 vccd1 _1356_ sky130_fd_sc_hd__nand3_1
XFILLER_0_71_162 vssd1 vssd1 vccd1 vccd1 sky130_fd_sc_hd__decap_6
X_4637_ clknet_leaf_25_clk _0438_ vssd1 vssd1 vccd1 vccd1 u_core.u_regfile.rf\[26\]\[7\]
+ sky130_fd_sc_hd__dfxtp_1
XFILLER_0_71_195 vssd1 vssd1 vccd1 vccd1 sky130_fd_sc_hd__fill_1
X_4568_ clknet_leaf_26_clk _0369_ vssd1 vssd1 vccd1 vccd1 u_core.u_regfile.rf\[27\]\[2\]
+ sky130_fd_sc_hd__dfxtp_1
X_3519_ _1764_ vssd1 vssd1 vccd1 vccd1 _0213_ sky130_fd_sc_hd__clkbuf_1
X_4499_ clknet_leaf_25_clk _0300_ vssd1 vssd1 vccd1 vccd1 u_core.u_regfile.rf\[30\]\[29\]
+ sky130_fd_sc_hd__dfxtp_1
XFILLER_0_23_505 vssd1 vssd1 vccd1 vccd1 sky130_fd_sc_hd__decap_4
Xclkbuf_leaf_20_clk clknet_2_3__leaf_clk vssd1 vssd1 vccd1 vccd1 clknet_leaf_20_clk
+ sky130_fd_sc_hd__clkbuf_16
XFILLER_0_81_27 vccd1 vssd1 vccd1 vssd1 sky130_ef_sc_hd__decap_12
XFILLER_0_58_402 vssd1 vssd1 vccd1 vccd1 sky130_fd_sc_hd__fill_2
XFILLER_0_58_446 vssd1 vssd1 vccd1 vccd1 sky130_fd_sc_hd__decap_6
XFILLER_0_85_265 vccd1 vssd1 vccd1 vssd1 sky130_ef_sc_hd__decap_12
X_3870_ net349 vssd1 vssd1 vccd1 vccd1 _1931_ sky130_fd_sc_hd__clkbuf_1
XFILLER_0_73_449 vssd1 vssd1 vccd1 vccd1 sky130_fd_sc_hd__decap_6
X_2821_ _1231_ _1225_ vssd1 vssd1 vccd1 vccd1 _1279_ sky130_fd_sc_hd__nand2_1
XFILLER_0_26_354 vssd1 vssd1 vccd1 vccd1 sky130_fd_sc_hd__decap_4
X_2752_ u_core.u_regfile.rf\[31\]\[20\] _0895_ _0874_ _0759_ vssd1 vssd1 vccd1 vccd1
+ _1210_ sky130_fd_sc_hd__a2bb2o_1
X_2683_ _1113_ _1138_ _1139_ _1140_ vssd1 vssd1 vccd1 vccd1 _1141_ sky130_fd_sc_hd__o211ai_1
XFILLER_0_41_335 vssd1 vssd1 vccd1 vccd1 sky130_fd_sc_hd__fill_1
X_4422_ clknet_leaf_9_clk _0233_ vssd1 vssd1 vccd1 vccd1 u_core.u_regfile.rf\[29\]\[26\]
+ sky130_fd_sc_hd__dfxtp_1
X_4353_ clknet_leaf_28_clk _0164_ vssd1 vssd1 vccd1 vccd1 u_core.u_regfile.rf\[5\]\[21\]
+ sky130_fd_sc_hd__dfxtp_1
X_3304_ net441 vssd1 vssd1 vccd1 vccd1 _1643_ sky130_fd_sc_hd__clkbuf_1
XTAP_232 vssd1 vccd1 sky130_fd_sc_hd__tapvpwrvgnd_1
XTAP_210 vssd1 vccd1 sky130_fd_sc_hd__tapvpwrvgnd_1
X_4284_ clknet_leaf_47_clk _0095_ vssd1 vssd1 vccd1 vccd1 u_core.u_regfile.rf\[6\]\[16\]
+ sky130_fd_sc_hd__dfxtp_1
XTAP_221 vssd1 vccd1 sky130_fd_sc_hd__tapvpwrvgnd_1
XTAP_265 vssd1 vccd1 sky130_fd_sc_hd__tapvpwrvgnd_1
XTAP_254 vssd1 vccd1 sky130_fd_sc_hd__tapvpwrvgnd_1
XTAP_243 vssd1 vccd1 sky130_fd_sc_hd__tapvpwrvgnd_1
X_3235_ u_core.u_regfile.rf\[31\]\[28\] vssd1 vssd1 vccd1 vccd1 _1619_ sky130_fd_sc_hd__clkbuf_1
XTAP_298 vssd1 vccd1 sky130_fd_sc_hd__tapvpwrvgnd_1
XTAP_287 vssd1 vccd1 sky130_fd_sc_hd__tapvpwrvgnd_1
XTAP_276 vssd1 vccd1 sky130_fd_sc_hd__tapvpwrvgnd_1
X_3166_ u_audio.counter\[1\] net34 net36 vssd1 vssd1 vccd1 vccd1 _1584_ sky130_fd_sc_hd__a21oi_1
X_3097_ _0606_ _1530_ _1532_ _0001_ vssd1 vssd1 vccd1 vccd1 _0015_ sky130_fd_sc_hd__a211oi_1
X_2117_ net548 vssd1 vssd1 vccd1 vccd1 _0576_ sky130_fd_sc_hd__inv_2
XFILLER_0_12_3 vccd1 vssd1 vccd1 vssd1 sky130_ef_sc_hd__decap_12
Xfanout25 net26 vssd1 vssd1 vccd1 vccd1 net25 sky130_fd_sc_hd__buf_2
XFILLER_0_76_265 vssd1 vssd1 vccd1 vccd1 sky130_fd_sc_hd__decap_8
XFILLER_0_49_479 vssd1 vssd1 vccd1 vccd1 sky130_fd_sc_hd__decap_8
XFILLER_0_64_416 vssd1 vssd1 vccd1 vccd1 sky130_fd_sc_hd__decap_4
XFILLER_0_71_93 vccd1 vssd1 vccd1 vssd1 sky130_ef_sc_hd__decap_12
X_3999_ _1995_ vssd1 vssd1 vccd1 vccd1 _0462_ sky130_fd_sc_hd__clkbuf_1
XFILLER_0_17_343 vssd1 vssd1 vccd1 vccd1 sky130_fd_sc_hd__decap_6
XFILLER_0_32_324 vssd1 vssd1 vccd1 vccd1 sky130_fd_sc_hd__decap_6
Xhold472 u_core.u_regfile.rf\[31\]\[15\] vssd1 vssd1 vccd1 vccd1 net505 sky130_fd_sc_hd__dlygate4sd3_1
Xhold461 u_core.u_regfile.rf\[28\]\[22\] vssd1 vssd1 vccd1 vccd1 net494 sky130_fd_sc_hd__dlygate4sd3_1
Xhold450 u_core.u_regfile.rf\[28\]\[25\] vssd1 vssd1 vccd1 vccd1 net483 sky130_fd_sc_hd__dlygate4sd3_1
Xhold494 u_timer.count_reg\[24\] vssd1 vssd1 vccd1 vccd1 net527 sky130_fd_sc_hd__dlygate4sd3_1
Xhold483 u_core.u_regfile.rf\[31\]\[11\] vssd1 vssd1 vccd1 vccd1 net516 sky130_fd_sc_hd__dlygate4sd3_1
XFILLER_0_70_419 vssd1 vssd1 vccd1 vccd1 sky130_fd_sc_hd__fill_1
XFILLER_0_63_460 vssd1 vssd1 vccd1 vccd1 sky130_fd_sc_hd__fill_2
XFILLER_0_2_229 vssd1 vssd1 vccd1 vccd1 sky130_fd_sc_hd__fill_2
XFILLER_0_11_508 vssd1 vssd1 vccd1 vccd1 sky130_fd_sc_hd__fill_2
XFILLER_0_76_27 vssd1 vssd1 vccd1 vccd1 sky130_fd_sc_hd__fill_1
Xclkbuf_leaf_0_clk clknet_2_0__leaf_clk vssd1 vssd1 vccd1 vccd1 clknet_leaf_0_clk
+ sky130_fd_sc_hd__clkbuf_16
X_3020_ _0768_ _1302_ _1315_ vssd1 vssd1 vccd1 vccd1 _1478_ sky130_fd_sc_hd__o21ai_1
X_3922_ net388 vssd1 vssd1 vccd1 vccd1 _1957_ sky130_fd_sc_hd__clkbuf_1
X_3853_ _1922_ vssd1 vssd1 vccd1 vccd1 _0389_ sky130_fd_sc_hd__clkbuf_1
X_2804_ _1260_ _1261_ vssd1 vssd1 vccd1 vccd1 _1262_ sky130_fd_sc_hd__nand2_1
X_3784_ _1876_ _1877_ net486 vssd1 vssd1 vccd1 vccd1 _1888_ sky130_fd_sc_hd__o21a_1
X_2735_ u_core.u_regfile.rf\[6\]\[17\] vssd1 vssd1 vccd1 vccd1 _1193_ sky130_fd_sc_hd__inv_2
XFILLER_0_41_110 vssd1 vssd1 vccd1 vccd1 sky130_fd_sc_hd__fill_2
X_2666_ _0866_ u_core.u_regfile.rf\[1\]\[7\] _0857_ _0867_ vssd1 vssd1 vccd1 vccd1
+ _1124_ sky130_fd_sc_hd__a31o_1
X_4405_ clknet_leaf_44_clk _0216_ vssd1 vssd1 vccd1 vccd1 u_core.u_regfile.rf\[29\]\[9\]
+ sky130_fd_sc_hd__dfxtp_1
X_2597_ u_core.u_regfile.rf\[4\]\[2\] _0749_ _0812_ vssd1 vssd1 vccd1 vccd1 _1055_
+ sky130_fd_sc_hd__o21ai_1
XFILLER_0_1_273 vssd1 vssd1 vccd1 vccd1 sky130_fd_sc_hd__decap_6
X_4336_ clknet_leaf_6_clk _0147_ vssd1 vssd1 vccd1 vccd1 u_core.u_regfile.rf\[5\]\[4\]
+ sky130_fd_sc_hd__dfxtp_1
X_4267_ clknet_leaf_4_clk _0006_ net33 vssd1 vssd1 vccd1 vccd1 u_imem.addr\[5\] sky130_fd_sc_hd__dfrtp_2
X_3218_ _1610_ vssd1 vssd1 vccd1 vccd1 _0066_ sky130_fd_sc_hd__clkbuf_1
X_4198_ net295 vssd1 vssd1 vccd1 vccd1 _2099_ sky130_fd_sc_hd__clkbuf_1
X_3149_ u_audio.counter\[0\] _1569_ u_audio.counter\[1\] _1567_ vssd1 vssd1 vccd1
+ vccd1 _1570_ sky130_fd_sc_hd__o22a_1
XFILLER_0_49_221 vssd1 vssd1 vccd1 vccd1 sky130_fd_sc_hd__decap_3
XFILLER_0_64_224 vssd1 vssd1 vccd1 vccd1 sky130_fd_sc_hd__decap_6
XFILLER_0_17_151 vssd1 vssd1 vccd1 vccd1 sky130_fd_sc_hd__fill_1
Xhold280 u_core.u_regfile.rf\[26\]\[31\] vssd1 vssd1 vccd1 vccd1 net313 sky130_fd_sc_hd__dlygate4sd3_1
Xhold291 u_core.u_regfile.rf\[30\]\[24\] vssd1 vssd1 vccd1 vccd1 net324 sky130_fd_sc_hd__dlygate4sd3_1
XFILLER_0_1_3 vccd1 vssd1 vccd1 vssd1 sky130_ef_sc_hd__decap_12
XFILLER_0_62_29 vssd1 vssd1 vccd1 vccd1 sky130_fd_sc_hd__fill_1
XFILLER_0_3_505 vssd1 vssd1 vccd1 vccd1 sky130_fd_sc_hd__decap_4
XFILLER_0_11_88 vssd1 vssd1 vccd1 vccd1 sky130_fd_sc_hd__fill_2
X_2520_ _0879_ u_core.u_regfile.rf\[5\]\[10\] _0724_ _0977_ vssd1 vssd1 vccd1 vccd1
+ _0978_ sky130_fd_sc_hd__o211a_1
X_2451_ _0699_ vssd1 vssd1 vccd1 vccd1 _0909_ sky130_fd_sc_hd__clkbuf_8
XFILLER_0_51_485 vssd1 vssd1 vccd1 vccd1 sky130_fd_sc_hd__fill_2
X_2382_ _0687_ vssd1 vssd1 vccd1 vccd1 _0840_ sky130_fd_sc_hd__buf_4
X_4121_ _2056_ vssd1 vssd1 vccd1 vccd1 _0523_ sky130_fd_sc_hd__clkbuf_1
X_4052_ net256 vssd1 vssd1 vccd1 vccd1 _2022_ sky130_fd_sc_hd__clkbuf_1
X_3003_ _1459_ _1460_ _0998_ vssd1 vssd1 vccd1 vccd1 _1461_ sky130_fd_sc_hd__o21ai_4
XFILLER_0_36_52 vssd1 vssd1 vccd1 vccd1 sky130_fd_sc_hd__fill_1
XFILLER_0_78_305 vssd1 vssd1 vccd1 vccd1 sky130_fd_sc_hd__decap_3
Xclkbuf_2_1__f_clk clknet_0_clk vssd1 vssd1 vccd1 vccd1 clknet_2_1__leaf_clk sky130_fd_sc_hd__clkbuf_16
XFILLER_0_19_449 vssd1 vssd1 vccd1 vccd1 sky130_fd_sc_hd__decap_4
X_3905_ _1948_ vssd1 vssd1 vccd1 vccd1 _0415_ sky130_fd_sc_hd__clkbuf_1
X_3836_ net191 vssd1 vssd1 vccd1 vccd1 _1914_ sky130_fd_sc_hd__clkbuf_1
XFILLER_0_34_419 vssd1 vssd1 vccd1 vccd1 sky130_fd_sc_hd__fill_1
XFILLER_0_46_279 vssd1 vssd1 vccd1 vccd1 sky130_fd_sc_hd__decap_3
XFILLER_0_6_365 vssd1 vssd1 vccd1 vccd1 sky130_fd_sc_hd__decap_6
X_3767_ _1458_ _1461_ _1875_ _1879_ vssd1 vssd1 vccd1 vccd1 _0346_ sky130_fd_sc_hd__a31o_1
X_2718_ _0952_ _1174_ _0702_ _0909_ _1175_ vssd1 vssd1 vccd1 vccd1 _1176_ sky130_fd_sc_hd__a221o_1
XFILLER_0_42_452 vssd1 vssd1 vccd1 vccd1 sky130_fd_sc_hd__decap_4
XFILLER_0_42_463 vssd1 vssd1 vccd1 vccd1 sky130_fd_sc_hd__fill_1
X_3698_ _1841_ vssd1 vssd1 vccd1 vccd1 _0315_ sky130_fd_sc_hd__clkbuf_1
X_2649_ _0913_ u_core.u_regfile.rf\[1\]\[6\] _0874_ _0914_ vssd1 vssd1 vccd1 vccd1
+ _1107_ sky130_fd_sc_hd__a31o_1
XFILLER_0_77_81 vccd1 vssd1 vccd1 vssd1 sky130_ef_sc_hd__decap_12
X_4319_ clknet_leaf_1_clk _0130_ vssd1 vssd1 vccd1 vccd1 u_core.u_regfile.rf\[4\]\[19\]
+ sky130_fd_sc_hd__dfxtp_1
XFILLER_0_77_393 vssd1 vssd1 vccd1 vccd1 sky130_fd_sc_hd__decap_8
XFILLER_0_37_213 vssd1 vssd1 vccd1 vccd1 sky130_fd_sc_hd__decap_8
XFILLER_0_45_290 vssd1 vssd1 vccd1 vccd1 sky130_fd_sc_hd__decap_8
XFILLER_0_52_249 vssd1 vssd1 vccd1 vccd1 sky130_fd_sc_hd__decap_3
XFILLER_0_20_157 vssd1 vssd1 vccd1 vccd1 sky130_fd_sc_hd__fill_1
XTAP_809 vssd1 vccd1 sky130_fd_sc_hd__tapvpwrvgnd_1
XFILLER_0_73_39 vccd1 vssd1 vccd1 vssd1 sky130_ef_sc_hd__decap_12
XFILLER_0_28_235 vssd1 vssd1 vccd1 vccd1 sky130_fd_sc_hd__fill_1
XFILLER_0_83_385 vssd1 vssd1 vccd1 vccd1 sky130_fd_sc_hd__decap_6
X_4670_ clknet_leaf_38_clk _0471_ vssd1 vssd1 vccd1 vccd1 u_core.u_regfile.rf\[24\]\[8\]
+ sky130_fd_sc_hd__dfxtp_1
X_3621_ net291 vssd1 vssd1 vccd1 vccd1 _1803_ sky130_fd_sc_hd__clkbuf_1
XFILLER_0_3_335 vssd1 vssd1 vccd1 vccd1 sky130_fd_sc_hd__fill_1
XFILLER_0_24_441 vssd1 vssd1 vccd1 vccd1 sky130_fd_sc_hd__decap_4
X_3552_ net434 vssd1 vssd1 vccd1 vccd1 _1781_ sky130_fd_sc_hd__clkbuf_1
X_2503_ _0881_ _0939_ u_core.u_regfile.rf\[4\]\[8\] vssd1 vssd1 vccd1 vccd1 _0961_
+ sky130_fd_sc_hd__a21o_1
X_3483_ _1731_ _1725_ _1739_ _1726_ _0600_ vssd1 vssd1 vccd1 vccd1 _1745_ sky130_fd_sc_hd__a41o_1
X_2434_ _0876_ _0878_ _0884_ _0891_ vssd1 vssd1 vccd1 vccd1 _0892_ sky130_fd_sc_hd__o211ai_1
X_2365_ _0738_ u_core.u_regfile.rf\[7\]\[25\] _0762_ _0751_ _0822_ vssd1 vssd1 vccd1
+ vccd1 _0823_ sky130_fd_sc_hd__o311a_1
X_4104_ net188 vssd1 vssd1 vccd1 vccd1 _2048_ sky130_fd_sc_hd__clkbuf_1
XFILLER_0_47_62 vssd1 vssd1 vccd1 vccd1 sky130_fd_sc_hd__fill_1
X_2296_ _0753_ vssd1 vssd1 vccd1 vccd1 _0754_ sky130_fd_sc_hd__clkbuf_4
X_4035_ _2013_ vssd1 vssd1 vccd1 vccd1 _0480_ sky130_fd_sc_hd__clkbuf_1
XFILLER_0_2_53 vccd1 vssd1 vccd1 vssd1 sky130_ef_sc_hd__decap_12
XPHY_108 vssd1 vssd1 vccd1 vccd1 sky130_fd_sc_hd__decap_3
XFILLER_0_59_371 vssd1 vssd1 vccd1 vccd1 sky130_fd_sc_hd__decap_4
XPHY_119 vssd1 vssd1 vccd1 vccd1 sky130_fd_sc_hd__decap_3
XFILLER_0_59_393 vssd1 vssd1 vccd1 vccd1 sky130_fd_sc_hd__decap_6
XFILLER_0_74_385 vssd1 vssd1 vccd1 vccd1 sky130_fd_sc_hd__decap_8
XFILLER_0_74_363 vssd1 vssd1 vccd1 vccd1 sky130_fd_sc_hd__fill_1
XFILLER_0_15_430 vssd1 vssd1 vccd1 vccd1 sky130_fd_sc_hd__fill_1
X_3819_ _1905_ vssd1 vssd1 vccd1 vccd1 _0372_ sky130_fd_sc_hd__clkbuf_1
X_4799_ clknet_leaf_10_clk _0567_ net21 vssd1 vssd1 vccd1 vccd1 u_audio.sample_reg\[0\]
+ sky130_fd_sc_hd__dfrtp_1
XFILLER_0_30_488 vssd1 vssd1 vccd1 vccd1 sky130_fd_sc_hd__decap_4
XFILLER_0_69_113 vccd1 vssd1 vccd1 vssd1 sky130_ef_sc_hd__decap_12
XFILLER_0_65_341 vssd1 vssd1 vccd1 vccd1 sky130_fd_sc_hd__fill_1
XFILLER_0_80_399 vccd1 vssd1 vccd1 vssd1 sky130_ef_sc_hd__decap_12
XFILLER_0_0_305 vssd1 vssd1 vccd1 vccd1 sky130_fd_sc_hd__decap_3
XFILLER_0_0_349 vccd1 vssd1 vccd1 vssd1 sky130_ef_sc_hd__decap_12
XTAP_606 vssd1 vccd1 sky130_fd_sc_hd__tapvpwrvgnd_1
XTAP_617 vssd1 vccd1 sky130_fd_sc_hd__tapvpwrvgnd_1
XTAP_628 vssd1 vccd1 sky130_fd_sc_hd__tapvpwrvgnd_1
XTAP_639 vssd1 vccd1 sky130_fd_sc_hd__tapvpwrvgnd_1
XFILLER_0_84_27 vssd1 vssd1 vccd1 vccd1 sky130_fd_sc_hd__fill_1
X_2150_ u_timer.count_reg\[19\] _0603_ u_timer.count_reg\[18\] _0604_ _0608_ vssd1
+ vssd1 vccd1 vccd1 _0609_ sky130_fd_sc_hd__a221o_1
XFILLER_0_75_105 vssd1 vssd1 vccd1 vccd1 sky130_fd_sc_hd__decap_6
XFILLER_0_75_138 vssd1 vssd1 vccd1 vccd1 sky130_fd_sc_hd__fill_2
X_2983_ _1114_ _1420_ vssd1 vssd1 vccd1 vccd1 _1441_ sky130_fd_sc_hd__nor2_1
XFILLER_0_56_330 vssd1 vssd1 vccd1 vccd1 sky130_fd_sc_hd__fill_2
X_4722_ clknet_leaf_34_clk _0523_ vssd1 vssd1 vccd1 vccd1 u_core.u_regfile.rf\[25\]\[28\]
+ sky130_fd_sc_hd__dfxtp_1
XFILLER_0_56_363 vssd1 vssd1 vccd1 vccd1 sky130_fd_sc_hd__fill_1
XFILLER_0_71_366 vssd1 vssd1 vccd1 vccd1 sky130_fd_sc_hd__fill_1
X_4653_ clknet_leaf_33_clk _0454_ vssd1 vssd1 vccd1 vccd1 u_core.u_regfile.rf\[26\]\[23\]
+ sky130_fd_sc_hd__dfxtp_1
X_3604_ _1794_ _1795_ _1796_ net87 vssd1 vssd1 vccd1 vccd1 _0266_ sky130_fd_sc_hd__o31a_1
X_4584_ clknet_leaf_31_clk _0385_ vssd1 vssd1 vccd1 vccd1 u_core.u_regfile.rf\[27\]\[18\]
+ sky130_fd_sc_hd__dfxtp_1
X_3535_ _1772_ vssd1 vssd1 vccd1 vccd1 _0221_ sky130_fd_sc_hd__clkbuf_1
XFILLER_0_24_282 vssd1 vssd1 vccd1 vccd1 sky130_fd_sc_hd__fill_2
XFILLER_0_12_477 vssd1 vssd1 vccd1 vccd1 sky130_fd_sc_hd__fill_2
X_3466_ u_timer.threshold_reg\[17\] vssd1 vssd1 vccd1 vccd1 _1733_ sky130_fd_sc_hd__inv_2
X_2417_ u_core.u_regfile.rf\[31\]\[12\] _0727_ _0874_ _0759_ vssd1 vssd1 vccd1 vccd1
+ _0875_ sky130_fd_sc_hd__a2bb2o_1
XFILLER_0_42_3 vccd1 vssd1 vccd1 vssd1 sky130_ef_sc_hd__decap_12
X_3397_ u_core.u_regfile.rf\[31\]\[0\] _0728_ _1133_ _1304_ vssd1 vssd1 vccd1 vccd1
+ _1681_ sky130_fd_sc_hd__a2bb2o_1
X_2348_ _0772_ _0774_ _0694_ u_core.u_regfile.rf\[5\]\[27\] _0805_ vssd1 vssd1 vccd1
+ vccd1 _0806_ sky130_fd_sc_hd__o221a_1
X_2279_ _0687_ u_imem.addr\[4\] vssd1 vssd1 vccd1 vccd1 _0737_ sky130_fd_sc_hd__nor2_4
X_4018_ net141 vssd1 vssd1 vccd1 vccd1 _2005_ sky130_fd_sc_hd__clkbuf_1
XFILLER_0_85_436 vccd1 vssd1 vccd1 vssd1 sky130_ef_sc_hd__decap_12
XFILLER_0_70_29 vssd1 vssd1 vccd1 vccd1 sky130_fd_sc_hd__decap_8
XFILLER_0_26_503 vssd1 vssd1 vccd1 vccd1 sky130_fd_sc_hd__decap_6
XFILLER_0_5_408 vssd1 vssd1 vccd1 vccd1 sky130_fd_sc_hd__fill_1
XFILLER_0_65_160 vssd1 vssd1 vccd1 vccd1 sky130_fd_sc_hd__decap_8
XFILLER_0_80_141 vssd1 vssd1 vccd1 vccd1 sky130_fd_sc_hd__fill_1
XFILLER_0_79_27 vccd1 vssd1 vccd1 vssd1 sky130_ef_sc_hd__decap_12
Xhold109 u_core.u_regfile.rf\[27\]\[22\] vssd1 vssd1 vccd1 vccd1 net142 sky130_fd_sc_hd__dlygate4sd3_1
X_3320_ net425 vssd1 vssd1 vccd1 vccd1 _1651_ sky130_fd_sc_hd__clkbuf_1
XFILLER_0_0_113 vccd1 vssd1 vccd1 vssd1 sky130_ef_sc_hd__decap_12
XTAP_403 vssd1 vccd1 sky130_fd_sc_hd__tapvpwrvgnd_1
XTAP_414 vssd1 vccd1 sky130_fd_sc_hd__tapvpwrvgnd_1
X_3251_ _1623_ _1624_ _1625_ net118 vssd1 vssd1 vccd1 vccd1 _0084_ sky130_fd_sc_hd__o31a_1
XTAP_425 vssd1 vccd1 sky130_fd_sc_hd__tapvpwrvgnd_1
XTAP_436 vssd1 vccd1 sky130_fd_sc_hd__tapvpwrvgnd_1
XTAP_447 vssd1 vccd1 sky130_fd_sc_hd__tapvpwrvgnd_1
XTAP_458 vssd1 vccd1 sky130_fd_sc_hd__tapvpwrvgnd_1
X_2202_ u_timer.count_reg\[16\] vssd1 vssd1 vccd1 vccd1 _0661_ sky130_fd_sc_hd__inv_2
XTAP_469 vssd1 vccd1 sky130_fd_sc_hd__tapvpwrvgnd_1
X_3182_ _1592_ vssd1 vssd1 vccd1 vccd1 _0048_ sky130_fd_sc_hd__clkbuf_1
X_2133_ u_timer.count_reg\[27\] vssd1 vssd1 vccd1 vccd1 _0592_ sky130_fd_sc_hd__inv_2
XFILLER_0_44_85 vssd1 vssd1 vccd1 vccd1 sky130_fd_sc_hd__fill_2
X_2966_ _1068_ _1050_ vssd1 vssd1 vccd1 vccd1 _1424_ sky130_fd_sc_hd__xnor2_1
X_4705_ clknet_leaf_36_clk _0506_ vssd1 vssd1 vccd1 vccd1 u_core.u_regfile.rf\[25\]\[11\]
+ sky130_fd_sc_hd__dfxtp_1
X_2897_ _1206_ _1354_ _1192_ vssd1 vssd1 vccd1 vccd1 _1355_ sky130_fd_sc_hd__o21ai_1
X_4636_ clknet_leaf_23_clk _0437_ vssd1 vssd1 vccd1 vccd1 u_core.u_regfile.rf\[26\]\[6\]
+ sky130_fd_sc_hd__dfxtp_1
XFILLER_0_8_41 vccd1 vssd1 vccd1 vssd1 sky130_ef_sc_hd__decap_12
X_4567_ clknet_leaf_38_clk _0368_ vssd1 vssd1 vccd1 vccd1 u_core.u_regfile.rf\[27\]\[1\]
+ sky130_fd_sc_hd__dfxtp_1
X_4498_ clknet_leaf_33_clk _0299_ vssd1 vssd1 vccd1 vccd1 u_core.u_regfile.rf\[30\]\[28\]
+ sky130_fd_sc_hd__dfxtp_1
X_3518_ net391 vssd1 vssd1 vccd1 vccd1 _1764_ sky130_fd_sc_hd__clkbuf_1
X_3449_ _1720_ _1704_ _1721_ vssd1 vssd1 vccd1 vccd1 _0186_ sky130_fd_sc_hd__o21ai_1
XFILLER_0_85_81 vssd1 vssd1 vccd1 vccd1 sky130_fd_sc_hd__decap_3
XFILLER_0_79_274 vssd1 vssd1 vccd1 vccd1 sky130_fd_sc_hd__decap_6
XFILLER_0_67_436 vssd1 vssd1 vccd1 vccd1 sky130_fd_sc_hd__fill_1
XFILLER_0_81_39 vccd1 vssd1 vccd1 vssd1 sky130_ef_sc_hd__decap_12
XFILLER_0_85_233 vssd1 vssd1 vccd1 vccd1 sky130_fd_sc_hd__fill_1
XFILLER_0_58_458 vssd1 vssd1 vccd1 vccd1 sky130_fd_sc_hd__fill_2
XFILLER_0_85_277 vssd1 vssd1 vccd1 vccd1 sky130_fd_sc_hd__decap_3
XFILLER_0_26_300 vssd1 vssd1 vccd1 vccd1 sky130_fd_sc_hd__decap_8
XFILLER_0_38_160 vssd1 vssd1 vccd1 vccd1 sky130_fd_sc_hd__fill_2
X_2820_ _0780_ _1277_ _1267_ vssd1 vssd1 vccd1 vccd1 _1278_ sky130_fd_sc_hd__or3b_2
XFILLER_0_5_216 vssd1 vssd1 vccd1 vccd1 sky130_fd_sc_hd__fill_2
X_2751_ _1166_ _1178_ _1192_ _1208_ vssd1 vssd1 vccd1 vccd1 _1209_ sky130_fd_sc_hd__nand4_2
XFILLER_0_81_461 vccd1 vssd1 vccd1 vssd1 sky130_ef_sc_hd__decap_12
X_2682_ _0776_ _0698_ _1132_ _1135_ _1128_ vssd1 vssd1 vccd1 vccd1 _1140_ sky130_fd_sc_hd__o41a_1
X_4421_ clknet_leaf_32_clk _0232_ vssd1 vssd1 vccd1 vccd1 u_core.u_regfile.rf\[29\]\[25\]
+ sky130_fd_sc_hd__dfxtp_1
X_4352_ clknet_leaf_28_clk _0163_ vssd1 vssd1 vccd1 vccd1 u_core.u_regfile.rf\[5\]\[20\]
+ sky130_fd_sc_hd__dfxtp_1
X_3303_ _1642_ vssd1 vssd1 vccd1 vccd1 _0119_ sky130_fd_sc_hd__clkbuf_1
X_4283_ clknet_leaf_48_clk _0094_ vssd1 vssd1 vccd1 vccd1 u_core.u_regfile.rf\[6\]\[15\]
+ sky130_fd_sc_hd__dfxtp_1
XTAP_233 vssd1 vccd1 sky130_fd_sc_hd__tapvpwrvgnd_1
XTAP_200 vssd1 vccd1 sky130_fd_sc_hd__tapvpwrvgnd_1
XTAP_211 vssd1 vccd1 sky130_fd_sc_hd__tapvpwrvgnd_1
XTAP_222 vssd1 vccd1 sky130_fd_sc_hd__tapvpwrvgnd_1
XTAP_266 vssd1 vccd1 sky130_fd_sc_hd__tapvpwrvgnd_1
XTAP_255 vssd1 vccd1 sky130_fd_sc_hd__tapvpwrvgnd_1
XTAP_244 vssd1 vccd1 sky130_fd_sc_hd__tapvpwrvgnd_1
X_3234_ _1618_ vssd1 vssd1 vccd1 vccd1 _0074_ sky130_fd_sc_hd__clkbuf_1
XTAP_299 vssd1 vccd1 sky130_fd_sc_hd__tapvpwrvgnd_1
XTAP_288 vssd1 vccd1 sky130_fd_sc_hd__tapvpwrvgnd_1
XTAP_277 vssd1 vccd1 sky130_fd_sc_hd__tapvpwrvgnd_1
X_3165_ u_audio.counter\[2\] u_audio.counter\[1\] net34 vssd1 vssd1 vccd1 vccd1 _1583_
+ sky130_fd_sc_hd__and3_1
X_3096_ u_timer.count_reg\[17\] u_timer.count_reg\[16\] u_timer.count_reg\[15\] _1525_
+ vssd1 vssd1 vccd1 vccd1 _1532_ sky130_fd_sc_hd__and4_1
X_2116_ net550 vssd1 vssd1 vccd1 vccd1 _0575_ sky130_fd_sc_hd__inv_2
XFILLER_0_55_73 vssd1 vssd1 vccd1 vccd1 sky130_fd_sc_hd__fill_1
Xfanout26 net33 vssd1 vssd1 vccd1 vccd1 net26 sky130_fd_sc_hd__clkbuf_4
X_3998_ net313 vssd1 vssd1 vccd1 vccd1 _1995_ sky130_fd_sc_hd__clkbuf_1
XFILLER_0_57_491 vccd1 vssd1 vccd1 vssd1 sky130_ef_sc_hd__decap_12
X_2949_ _0782_ _1406_ _0775_ vssd1 vssd1 vccd1 vccd1 _1407_ sky130_fd_sc_hd__o21a_1
XFILLER_0_32_303 vssd1 vssd1 vccd1 vccd1 sky130_fd_sc_hd__decap_4
X_4619_ clknet_leaf_41_clk _0420_ vssd1 vssd1 vccd1 vccd1 u_core.u_regfile.rf\[1\]\[21\]
+ sky130_fd_sc_hd__dfxtp_1
XFILLER_0_20_509 vssd1 vssd1 vccd1 vccd1 sky130_fd_sc_hd__fill_1
Xhold451 u_timer.count_reg\[19\] vssd1 vssd1 vccd1 vccd1 net484 sky130_fd_sc_hd__dlygate4sd3_1
Xhold462 u_timer.threshold_reg\[5\] vssd1 vssd1 vccd1 vccd1 net495 sky130_fd_sc_hd__dlygate4sd3_1
Xhold440 u_audio.sample_reg\[0\] vssd1 vssd1 vccd1 vccd1 net473 sky130_fd_sc_hd__dlygate4sd3_1
Xhold473 u_core.u_regfile.rf\[28\]\[7\] vssd1 vssd1 vccd1 vccd1 net506 sky130_fd_sc_hd__dlygate4sd3_1
Xhold495 u_core.u_regfile.rf\[31\]\[7\] vssd1 vssd1 vccd1 vccd1 net528 sky130_fd_sc_hd__dlygate4sd3_1
Xhold484 u_audio.sample_reg\[6\] vssd1 vssd1 vccd1 vccd1 net517 sky130_fd_sc_hd__dlygate4sd3_1
XFILLER_0_67_200 vssd1 vssd1 vccd1 vccd1 sky130_fd_sc_hd__fill_1
XFILLER_0_35_185 vssd1 vssd1 vccd1 vccd1 sky130_fd_sc_hd__fill_2
XFILLER_0_63_494 vssd1 vssd1 vccd1 vccd1 sky130_fd_sc_hd__decap_8
XFILLER_0_50_166 vssd1 vssd1 vccd1 vccd1 sky130_fd_sc_hd__decap_3
XFILLER_0_78_509 vssd1 vssd1 vccd1 vccd1 sky130_fd_sc_hd__fill_1
X_3921_ _1956_ vssd1 vssd1 vccd1 vccd1 _0423_ sky130_fd_sc_hd__clkbuf_1
X_3852_ net142 vssd1 vssd1 vccd1 vccd1 _1922_ sky130_fd_sc_hd__clkbuf_1
XFILLER_0_73_225 vccd1 vssd1 vccd1 vssd1 sky130_ef_sc_hd__decap_12
XFILLER_0_18_119 vssd1 vssd1 vccd1 vccd1 sky130_fd_sc_hd__fill_1
XFILLER_0_58_288 vssd1 vssd1 vccd1 vccd1 sky130_fd_sc_hd__decap_3
X_2803_ u_core.u_regfile.rf\[1\]\[22\] _0742_ _0738_ _0710_ vssd1 vssd1 vccd1 vccd1
+ _1261_ sky130_fd_sc_hd__o2bb2a_1
XFILLER_0_39_491 vccd1 vssd1 vccd1 vssd1 sky130_ef_sc_hd__decap_12
X_3783_ net102 _1861_ _1887_ vssd1 vssd1 vccd1 vccd1 _0354_ sky130_fd_sc_hd__a21o_1
X_2734_ _1190_ _1191_ vssd1 vssd1 vccd1 vccd1 _1192_ sky130_fd_sc_hd__nor2_1
X_2665_ _0700_ _0939_ u_core.u_regfile.rf\[4\]\[7\] vssd1 vssd1 vccd1 vccd1 _1123_
+ sky130_fd_sc_hd__a21o_1
X_2596_ _0757_ net20 u_core.u_regfile.rf\[6\]\[2\] vssd1 vssd1 vccd1 vccd1 _1054_
+ sky130_fd_sc_hd__o21ai_1
X_4404_ clknet_leaf_41_clk _0215_ vssd1 vssd1 vccd1 vccd1 u_core.u_regfile.rf\[29\]\[8\]
+ sky130_fd_sc_hd__dfxtp_1
XFILLER_0_41_177 vssd1 vssd1 vccd1 vccd1 sky130_fd_sc_hd__fill_2
X_4335_ clknet_leaf_6_clk _0146_ vssd1 vssd1 vccd1 vccd1 u_core.u_regfile.rf\[5\]\[3\]
+ sky130_fd_sc_hd__dfxtp_1
X_4266_ clknet_leaf_4_clk _0005_ net33 vssd1 vssd1 vccd1 vccd1 u_imem.addr\[4\] sky130_fd_sc_hd__dfrtp_4
X_4197_ _2098_ vssd1 vssd1 vccd1 vccd1 _0557_ sky130_fd_sc_hd__clkbuf_1
X_3217_ net559 vssd1 vssd1 vccd1 vccd1 _1610_ sky130_fd_sc_hd__clkbuf_1
X_3148_ net473 vssd1 vssd1 vccd1 vccd1 _1569_ sky130_fd_sc_hd__inv_2
XFILLER_0_69_509 vssd1 vssd1 vccd1 vccd1 sky130_fd_sc_hd__fill_1
X_3079_ u_timer.count_reg\[11\] u_timer.count_reg\[10\] _1518_ u_timer.count_reg\[12\]
+ vssd1 vssd1 vccd1 vccd1 _1520_ sky130_fd_sc_hd__a31o_1
XFILLER_0_45_483 vssd1 vssd1 vccd1 vccd1 sky130_fd_sc_hd__decap_8
XFILLER_0_45_494 vssd1 vssd1 vccd1 vccd1 sky130_fd_sc_hd__fill_1
XFILLER_0_20_306 vssd1 vssd1 vccd1 vccd1 sky130_fd_sc_hd__fill_2
XFILLER_0_32_188 vssd1 vssd1 vccd1 vccd1 sky130_fd_sc_hd__fill_1
Xhold270 u_core.u_regfile.rf\[27\]\[17\] vssd1 vssd1 vccd1 vccd1 net303 sky130_fd_sc_hd__dlygate4sd3_1
Xhold292 u_core.u_regfile.rf\[24\]\[19\] vssd1 vssd1 vccd1 vccd1 net325 sky130_fd_sc_hd__dlygate4sd3_1
Xhold281 u_core.u_regfile.rf\[2\]\[15\] vssd1 vssd1 vccd1 vccd1 net314 sky130_fd_sc_hd__dlygate4sd3_1
XFILLER_0_28_417 vssd1 vssd1 vccd1 vccd1 sky130_fd_sc_hd__decap_3
XFILLER_0_55_225 vssd1 vssd1 vccd1 vccd1 sky130_fd_sc_hd__fill_2
XFILLER_0_23_100 vssd1 vssd1 vccd1 vccd1 sky130_fd_sc_hd__fill_2
XFILLER_0_36_483 vssd1 vssd1 vccd1 vccd1 sky130_fd_sc_hd__fill_1
X_2450_ u_core.u_regfile.rf\[6\]\[13\] vssd1 vssd1 vccd1 vccd1 _0908_ sky130_fd_sc_hd__inv_2
X_2381_ u_core.u_regfile.rf\[31\]\[24\] _0727_ _0746_ _0716_ _0838_ vssd1 vssd1 vccd1
+ vccd1 _0839_ sky130_fd_sc_hd__o221ai_4
X_4120_ net213 vssd1 vssd1 vccd1 vccd1 _2056_ sky130_fd_sc_hd__clkbuf_1
X_4051_ _2021_ vssd1 vssd1 vccd1 vccd1 _0488_ sky130_fd_sc_hd__clkbuf_1
X_3002_ _0967_ _1450_ _1449_ vssd1 vssd1 vccd1 vccd1 _1460_ sky130_fd_sc_hd__a21oi_1
XFILLER_0_52_41 vssd1 vssd1 vccd1 vccd1 sky130_fd_sc_hd__fill_1
XFILLER_0_74_501 vssd1 vssd1 vccd1 vccd1 sky130_fd_sc_hd__decap_4
X_3904_ net502 vssd1 vssd1 vccd1 vccd1 _1948_ sky130_fd_sc_hd__clkbuf_1
X_3835_ _1913_ vssd1 vssd1 vccd1 vccd1 _0380_ sky130_fd_sc_hd__clkbuf_1
XFILLER_0_14_111 vssd1 vssd1 vccd1 vccd1 sky130_fd_sc_hd__fill_1
X_3766_ _1876_ _1877_ net454 vssd1 vssd1 vccd1 vccd1 _1879_ sky130_fd_sc_hd__o21a_1
XFILLER_0_61_228 vssd1 vssd1 vccd1 vccd1 sky130_fd_sc_hd__fill_1
X_2717_ _0758_ _0954_ u_core.u_regfile.rf\[28\]\[16\] vssd1 vssd1 vccd1 vccd1 _1175_
+ sky130_fd_sc_hd__o21a_1
XFILLER_0_72_3 vccd1 vssd1 vccd1 vssd1 sky130_ef_sc_hd__decap_12
X_3697_ net300 vssd1 vssd1 vccd1 vccd1 _1841_ sky130_fd_sc_hd__clkbuf_1
XFILLER_0_42_475 vssd1 vssd1 vccd1 vccd1 sky130_fd_sc_hd__fill_1
X_2648_ u_core.u_regfile.rf\[5\]\[6\] _0879_ _1103_ _1105_ _0724_ vssd1 vssd1 vccd1
+ vccd1 _1106_ sky130_fd_sc_hd__o221ai_4
X_2579_ u_core.u_regfile.rf\[7\]\[1\] vssd1 vssd1 vccd1 vccd1 _1037_ sky130_fd_sc_hd__inv_2
XFILLER_0_77_93 vccd1 vssd1 vccd1 vssd1 sky130_ef_sc_hd__decap_12
X_4318_ clknet_leaf_0_clk _0129_ vssd1 vssd1 vccd1 vccd1 u_core.u_regfile.rf\[4\]\[18\]
+ sky130_fd_sc_hd__dfxtp_1
X_4249_ clknet_leaf_41_clk _0064_ vssd1 vssd1 vccd1 vccd1 u_core.u_regfile.rf\[31\]\[17\]
+ sky130_fd_sc_hd__dfxtp_1
XFILLER_0_37_225 vssd1 vssd1 vccd1 vccd1 sky130_fd_sc_hd__decap_3
XFILLER_0_33_431 vssd1 vssd1 vccd1 vccd1 sky130_fd_sc_hd__fill_1
XFILLER_0_60_250 vssd1 vssd1 vccd1 vccd1 sky130_fd_sc_hd__fill_2
XFILLER_0_0_509 vssd1 vssd1 vccd1 vccd1 sky130_fd_sc_hd__fill_1
XFILLER_0_22_55 vssd1 vssd1 vccd1 vccd1 sky130_fd_sc_hd__decap_6
X_3620_ _1802_ vssd1 vssd1 vccd1 vccd1 _0276_ sky130_fd_sc_hd__clkbuf_1
X_3551_ _1780_ vssd1 vssd1 vccd1 vccd1 _0229_ sky130_fd_sc_hd__clkbuf_1
X_2502_ _0958_ _0754_ _0714_ _0959_ _0909_ vssd1 vssd1 vccd1 vccd1 _0960_ sky130_fd_sc_hd__o2111ai_4
X_3482_ _1279_ _1741_ _1744_ vssd1 vssd1 vccd1 vccd1 _0196_ sky130_fd_sc_hd__o21ai_1
X_2433_ _0889_ _0890_ vssd1 vssd1 vccd1 vccd1 _0891_ sky130_fd_sc_hd__nand2_1
X_2364_ _0754_ _0803_ u_core.u_regfile.rf\[6\]\[25\] vssd1 vssd1 vccd1 vccd1 _0822_
+ sky130_fd_sc_hd__a21o_1
X_4103_ _2047_ vssd1 vssd1 vccd1 vccd1 _0514_ sky130_fd_sc_hd__clkbuf_1
X_2295_ _0685_ _0752_ _0695_ vssd1 vssd1 vccd1 vccd1 _0753_ sky130_fd_sc_hd__nand3_2
X_4034_ net268 vssd1 vssd1 vccd1 vccd1 _2013_ sky130_fd_sc_hd__clkbuf_1
XFILLER_0_2_65 vssd1 vssd1 vccd1 vccd1 sky130_fd_sc_hd__fill_2
XFILLER_0_63_51 vssd1 vssd1 vccd1 vccd1 sky130_fd_sc_hd__decap_4
XFILLER_0_2_98 vssd1 vssd1 vccd1 vccd1 sky130_fd_sc_hd__decap_3
XFILLER_0_63_73 vssd1 vssd1 vccd1 vccd1 sky130_fd_sc_hd__fill_2
XPHY_109 vssd1 vssd1 vccd1 vccd1 sky130_fd_sc_hd__decap_3
XFILLER_0_19_225 vssd1 vssd1 vccd1 vccd1 sky130_fd_sc_hd__decap_4
XFILLER_0_34_206 vssd1 vssd1 vccd1 vccd1 sky130_fd_sc_hd__decap_8
XFILLER_0_62_504 vssd1 vssd1 vccd1 vccd1 sky130_fd_sc_hd__decap_6
XFILLER_0_15_420 vssd1 vssd1 vccd1 vccd1 sky130_fd_sc_hd__decap_3
XFILLER_0_6_130 vssd1 vssd1 vccd1 vccd1 sky130_fd_sc_hd__decap_3
X_3818_ net231 vssd1 vssd1 vccd1 vccd1 _1905_ sky130_fd_sc_hd__clkbuf_1
X_4798_ clknet_leaf_37_clk _0566_ vssd1 vssd1 vccd1 vccd1 u_core.u_regfile.rf\[3\]\[31\]
+ sky130_fd_sc_hd__dfxtp_1
X_3749_ _1133_ vssd1 vssd1 vccd1 vccd1 _1868_ sky130_fd_sc_hd__buf_4
XFILLER_0_30_445 vssd1 vssd1 vccd1 vccd1 sky130_fd_sc_hd__fill_1
XFILLER_0_42_294 vssd1 vssd1 vccd1 vccd1 sky130_fd_sc_hd__fill_1
Xmax_cap12 net13 vssd1 vssd1 vccd1 vccd1 net12 sky130_fd_sc_hd__clkbuf_2
XFILLER_0_69_125 vssd1 vssd1 vccd1 vccd1 sky130_fd_sc_hd__fill_1
XFILLER_0_33_272 vssd1 vssd1 vccd1 vccd1 sky130_fd_sc_hd__decap_4
XFILLER_0_68_29 vssd1 vssd1 vccd1 vccd1 sky130_fd_sc_hd__decap_8
XTAP_607 vssd1 vccd1 sky130_fd_sc_hd__tapvpwrvgnd_1
XTAP_618 vssd1 vccd1 sky130_fd_sc_hd__tapvpwrvgnd_1
XTAP_629 vssd1 vccd1 sky130_fd_sc_hd__tapvpwrvgnd_1
X_2982_ _1139_ _1439_ _1129_ _1113_ vssd1 vssd1 vccd1 vccd1 _1440_ sky130_fd_sc_hd__a211o_1
XFILLER_0_68_191 vssd1 vssd1 vccd1 vccd1 sky130_fd_sc_hd__fill_1
X_4721_ clknet_leaf_37_clk _0522_ vssd1 vssd1 vccd1 vccd1 u_core.u_regfile.rf\[25\]\[27\]
+ sky130_fd_sc_hd__dfxtp_1
XFILLER_0_56_342 vssd1 vssd1 vccd1 vccd1 sky130_fd_sc_hd__fill_1
X_4652_ clknet_leaf_36_clk _0453_ vssd1 vssd1 vccd1 vccd1 u_core.u_regfile.rf\[26\]\[22\]
+ sky130_fd_sc_hd__dfxtp_1
X_3603_ _1794_ _1795_ _1796_ net64 vssd1 vssd1 vccd1 vccd1 _0265_ sky130_fd_sc_hd__o31a_1
XFILLER_0_12_412 vssd1 vssd1 vccd1 vccd1 sky130_fd_sc_hd__decap_8
X_4583_ clknet_leaf_27_clk _0384_ vssd1 vssd1 vccd1 vccd1 u_core.u_regfile.rf\[27\]\[17\]
+ sky130_fd_sc_hd__dfxtp_1
XFILLER_0_12_445 vssd1 vssd1 vccd1 vccd1 sky130_fd_sc_hd__decap_6
XFILLER_0_3_166 vssd1 vssd1 vccd1 vccd1 sky130_fd_sc_hd__fill_2
XFILLER_0_3_177 vssd1 vssd1 vccd1 vccd1 sky130_fd_sc_hd__fill_1
X_3534_ net373 vssd1 vssd1 vccd1 vccd1 _1772_ sky130_fd_sc_hd__clkbuf_1
XFILLER_0_12_467 vssd1 vssd1 vccd1 vccd1 sky130_fd_sc_hd__decap_8
X_3465_ _1730_ _1704_ _1732_ vssd1 vssd1 vccd1 vccd1 _0191_ sky130_fd_sc_hd__o21ai_1
X_2416_ _0857_ vssd1 vssd1 vccd1 vccd1 _0874_ sky130_fd_sc_hd__clkbuf_4
X_3396_ _1679_ vssd1 vssd1 vccd1 vccd1 _1680_ sky130_fd_sc_hd__buf_2
XFILLER_0_35_3 vssd1 vssd1 vccd1 vccd1 sky130_fd_sc_hd__decap_8
X_2347_ u_core.u_regfile.rf\[28\]\[27\] _0697_ _0701_ _0703_ _0804_ vssd1 vssd1 vccd1
+ vccd1 _0805_ sky130_fd_sc_hd__a221o_1
X_2278_ _0735_ vssd1 vssd1 vccd1 vccd1 _0736_ sky130_fd_sc_hd__buf_4
XFILLER_0_74_83 vssd1 vssd1 vccd1 vccd1 sky130_fd_sc_hd__fill_1
X_4017_ _2004_ vssd1 vssd1 vccd1 vccd1 _0471_ sky130_fd_sc_hd__clkbuf_1
XFILLER_0_74_183 vssd1 vssd1 vccd1 vccd1 sky130_fd_sc_hd__decap_4
XFILLER_0_47_386 vssd1 vssd1 vccd1 vccd1 sky130_fd_sc_hd__fill_1
XFILLER_0_7_494 vssd1 vssd1 vccd1 vccd1 sky130_fd_sc_hd__decap_8
XFILLER_0_30_242 vssd1 vssd1 vccd1 vccd1 sky130_fd_sc_hd__fill_1
XFILLER_0_80_164 vccd1 vssd1 vccd1 vssd1 sky130_ef_sc_hd__decap_12
XFILLER_0_79_39 vccd1 vssd1 vccd1 vssd1 sky130_ef_sc_hd__decap_12
XFILLER_0_0_125 vccd1 vssd1 vccd1 vssd1 sky130_ef_sc_hd__decap_12
XFILLER_0_0_169 vssd1 vssd1 vccd1 vccd1 sky130_fd_sc_hd__decap_8
XTAP_404 vssd1 vccd1 sky130_fd_sc_hd__tapvpwrvgnd_1
XTAP_415 vssd1 vccd1 sky130_fd_sc_hd__tapvpwrvgnd_1
X_3250_ _1623_ _1624_ _1625_ net81 vssd1 vssd1 vccd1 vccd1 _0083_ sky130_fd_sc_hd__o31a_1
XTAP_426 vssd1 vccd1 sky130_fd_sc_hd__tapvpwrvgnd_1
XTAP_437 vssd1 vccd1 sky130_fd_sc_hd__tapvpwrvgnd_1
XTAP_448 vssd1 vccd1 sky130_fd_sc_hd__tapvpwrvgnd_1
X_2201_ _0619_ _0633_ _0653_ _0659_ vssd1 vssd1 vccd1 vccd1 _0660_ sky130_fd_sc_hd__o31ai_1
XFILLER_0_28_43 vccd1 vssd1 vccd1 vssd1 sky130_ef_sc_hd__decap_12
XTAP_459 vssd1 vccd1 sky130_fd_sc_hd__tapvpwrvgnd_1
X_3181_ net498 vssd1 vssd1 vccd1 vccd1 _1592_ sky130_fd_sc_hd__clkbuf_1
X_2132_ u_timer.count_reg\[26\] vssd1 vssd1 vccd1 vccd1 _0591_ sky130_fd_sc_hd__inv_2
XFILLER_0_44_53 vssd1 vssd1 vccd1 vccd1 sky130_fd_sc_hd__decap_3
XFILLER_0_48_139 vssd1 vssd1 vccd1 vccd1 sky130_fd_sc_hd__fill_1
X_4704_ clknet_leaf_36_clk _0505_ vssd1 vssd1 vccd1 vccd1 u_core.u_regfile.rf\[25\]\[10\]
+ sky130_fd_sc_hd__dfxtp_1
X_2965_ _1070_ _1022_ vssd1 vssd1 vccd1 vccd1 _1423_ sky130_fd_sc_hd__xnor2_1
X_2896_ _1351_ _1352_ _1353_ _1285_ vssd1 vssd1 vccd1 vccd1 _1354_ sky130_fd_sc_hd__a22oi_2
XFILLER_0_60_85 vssd1 vssd1 vccd1 vccd1 sky130_fd_sc_hd__fill_1
X_4635_ clknet_leaf_19_clk _0436_ vssd1 vssd1 vccd1 vccd1 u_core.u_regfile.rf\[26\]\[5\]
+ sky130_fd_sc_hd__dfxtp_1
XFILLER_0_8_53 vssd1 vssd1 vccd1 vccd1 sky130_fd_sc_hd__decap_3
XFILLER_0_4_475 vssd1 vssd1 vccd1 vccd1 sky130_fd_sc_hd__fill_1
X_4566_ clknet_leaf_25_clk _0367_ vssd1 vssd1 vccd1 vccd1 u_core.u_regfile.rf\[27\]\[0\]
+ sky130_fd_sc_hd__dfxtp_1
X_3517_ _1763_ vssd1 vssd1 vccd1 vccd1 _0212_ sky130_fd_sc_hd__clkbuf_1
XFILLER_0_69_72 vssd1 vssd1 vccd1 vccd1 sky130_fd_sc_hd__fill_2
X_4497_ clknet_leaf_19_clk _0298_ vssd1 vssd1 vccd1 vccd1 u_core.u_regfile.rf\[30\]\[27\]
+ sky130_fd_sc_hd__dfxtp_1
X_3448_ _1705_ _1706_ _1714_ _1715_ _0621_ vssd1 vssd1 vccd1 vccd1 _1721_ sky130_fd_sc_hd__a41o_1
XTAP_960 vssd1 vccd1 sky130_fd_sc_hd__tapvpwrvgnd_1
X_3379_ _1671_ _1672_ _1673_ net374 vssd1 vssd1 vccd1 vccd1 _0164_ sky130_fd_sc_hd__o31a_1
XFILLER_0_67_426 vssd1 vssd1 vccd1 vccd1 sky130_fd_sc_hd__fill_1
XFILLER_0_50_348 vssd1 vssd1 vccd1 vccd1 sky130_fd_sc_hd__fill_1
XFILLER_0_85_223 vssd1 vssd1 vccd1 vccd1 sky130_fd_sc_hd__fill_1
XFILLER_0_5_228 vccd1 vssd1 vccd1 vssd1 sky130_ef_sc_hd__decap_12
X_2750_ _1206_ _1207_ vssd1 vssd1 vccd1 vccd1 _1208_ sky130_fd_sc_hd__nor2_1
XFILLER_0_81_473 vccd1 vssd1 vccd1 vssd1 sky130_ef_sc_hd__decap_12
X_2681_ _0917_ _1112_ _1106_ vssd1 vssd1 vccd1 vccd1 _1139_ sky130_fd_sc_hd__o21ai_1
XFILLER_0_53_175 vssd1 vssd1 vccd1 vccd1 sky130_fd_sc_hd__fill_1
X_4420_ clknet_leaf_26_clk _0231_ vssd1 vssd1 vccd1 vccd1 u_core.u_regfile.rf\[29\]\[24\]
+ sky130_fd_sc_hd__dfxtp_1
X_4351_ clknet_leaf_30_clk _0162_ vssd1 vssd1 vccd1 vccd1 u_core.u_regfile.rf\[5\]\[19\]
+ sky130_fd_sc_hd__dfxtp_1
X_3302_ net426 vssd1 vssd1 vccd1 vccd1 _1642_ sky130_fd_sc_hd__clkbuf_1
X_4282_ clknet_leaf_47_clk _0093_ vssd1 vssd1 vccd1 vccd1 u_core.u_regfile.rf\[6\]\[14\]
+ sky130_fd_sc_hd__dfxtp_1
XTAP_201 vssd1 vccd1 sky130_fd_sc_hd__tapvpwrvgnd_1
XTAP_212 vssd1 vccd1 sky130_fd_sc_hd__tapvpwrvgnd_1
XTAP_223 vssd1 vccd1 sky130_fd_sc_hd__tapvpwrvgnd_1
XTAP_256 vssd1 vccd1 sky130_fd_sc_hd__tapvpwrvgnd_1
XTAP_245 vssd1 vccd1 sky130_fd_sc_hd__tapvpwrvgnd_1
XTAP_234 vssd1 vccd1 sky130_fd_sc_hd__tapvpwrvgnd_1
X_3233_ net557 vssd1 vssd1 vccd1 vccd1 _1618_ sky130_fd_sc_hd__clkbuf_1
XTAP_289 vssd1 vccd1 sky130_fd_sc_hd__tapvpwrvgnd_1
XTAP_278 vssd1 vccd1 sky130_fd_sc_hd__tapvpwrvgnd_1
XTAP_267 vssd1 vccd1 sky130_fd_sc_hd__tapvpwrvgnd_1
X_3164_ u_audio.counter\[1\] net34 vssd1 vssd1 vccd1 vccd1 _0040_ sky130_fd_sc_hd__xor2_1
X_3095_ _1531_ vssd1 vssd1 vccd1 vccd1 _0014_ sky130_fd_sc_hd__clkbuf_1
Xfanout27 net32 vssd1 vssd1 vccd1 vccd1 net27 sky130_fd_sc_hd__clkbuf_4
X_3997_ _1994_ vssd1 vssd1 vccd1 vccd1 _0461_ sky130_fd_sc_hd__clkbuf_1
X_2948_ u_core.u_regfile.rf\[31\]\[29\] _0728_ _0783_ _1405_ _0766_ vssd1 vssd1 vccd1
+ vccd1 _1406_ sky130_fd_sc_hd__o221ai_4
X_4618_ clknet_leaf_45_clk _0419_ vssd1 vssd1 vccd1 vccd1 u_core.u_regfile.rf\[1\]\[20\]
+ sky130_fd_sc_hd__dfxtp_1
XFILLER_0_4_250 vssd1 vssd1 vccd1 vccd1 sky130_fd_sc_hd__fill_2
XFILLER_0_44_197 vssd1 vssd1 vccd1 vccd1 sky130_fd_sc_hd__decap_8
X_2879_ _1333_ _1336_ _0850_ vssd1 vssd1 vccd1 vccd1 _1337_ sky130_fd_sc_hd__a21boi_2
Xhold452 _0017_ vssd1 vssd1 vccd1 vccd1 net485 sky130_fd_sc_hd__dlygate4sd3_1
X_4549_ clknet_leaf_29_clk _0350_ vssd1 vssd1 vccd1 vccd1 u_core.u_regfile.rf\[28\]\[15\]
+ sky130_fd_sc_hd__dfxtp_1
Xhold430 u_core.u_regfile.rf\[1\]\[28\] vssd1 vssd1 vccd1 vccd1 net463 sky130_fd_sc_hd__dlygate4sd3_1
Xhold441 u_core.u_regfile.rf\[1\]\[30\] vssd1 vssd1 vccd1 vccd1 net474 sky130_fd_sc_hd__dlygate4sd3_1
Xhold463 u_core.u_regfile.rf\[28\]\[24\] vssd1 vssd1 vccd1 vccd1 net496 sky130_fd_sc_hd__dlygate4sd3_1
Xhold485 u_core.u_regfile.rf\[28\]\[17\] vssd1 vssd1 vccd1 vccd1 net518 sky130_fd_sc_hd__dlygate4sd3_1
Xhold496 u_core.u_regfile.rf\[28\]\[30\] vssd1 vssd1 vccd1 vccd1 net529 sky130_fd_sc_hd__dlygate4sd3_1
Xhold474 net7 vssd1 vssd1 vccd1 vccd1 net507 sky130_fd_sc_hd__dlygate4sd3_1
XTAP_790 vssd1 vccd1 sky130_fd_sc_hd__tapvpwrvgnd_1
XFILLER_0_63_440 vssd1 vssd1 vccd1 vccd1 sky130_fd_sc_hd__fill_2
XFILLER_0_35_164 vssd1 vssd1 vccd1 vccd1 sky130_fd_sc_hd__decap_4
XFILLER_0_2_209 vccd1 vssd1 vccd1 vssd1 sky130_ef_sc_hd__decap_12
XFILLER_0_50_101 vssd1 vssd1 vccd1 vccd1 sky130_fd_sc_hd__fill_2
XFILLER_0_50_134 vssd1 vssd1 vccd1 vccd1 sky130_fd_sc_hd__fill_1
XFILLER_0_23_359 vssd1 vssd1 vccd1 vccd1 sky130_fd_sc_hd__decap_3
XFILLER_0_50_189 vssd1 vssd1 vccd1 vccd1 sky130_fd_sc_hd__decap_6
XFILLER_0_76_29 vccd1 vssd1 vccd1 vssd1 sky130_ef_sc_hd__decap_12
X_3920_ net380 vssd1 vssd1 vccd1 vccd1 _1956_ sky130_fd_sc_hd__clkbuf_1
XFILLER_0_73_215 vssd1 vssd1 vccd1 vccd1 sky130_fd_sc_hd__decap_8
X_3851_ _1921_ vssd1 vssd1 vccd1 vccd1 _0388_ sky130_fd_sc_hd__clkbuf_1
XFILLER_0_73_237 vssd1 vssd1 vccd1 vccd1 sky130_fd_sc_hd__fill_2
X_2802_ _1257_ _1258_ _1259_ vssd1 vssd1 vccd1 vccd1 _1260_ sky130_fd_sc_hd__o21ai_2
X_3782_ _1191_ _1356_ _0783_ _1358_ vssd1 vssd1 vccd1 vccd1 _1887_ sky130_fd_sc_hd__o211a_1
XFILLER_0_54_440 vccd1 vssd1 vccd1 vssd1 sky130_ef_sc_hd__decap_12
X_2733_ _1185_ _1189_ _0735_ vssd1 vssd1 vccd1 vccd1 _1191_ sky130_fd_sc_hd__and3_2
XFILLER_0_81_281 vssd1 vssd1 vccd1 vccd1 sky130_fd_sc_hd__fill_2
X_2664_ _1120_ _0938_ _0939_ _1121_ _0881_ vssd1 vssd1 vccd1 vccd1 _1122_ sky130_fd_sc_hd__o2111ai_4
X_2595_ _0860_ u_core.u_regfile.rf\[7\]\[2\] _0713_ vssd1 vssd1 vccd1 vccd1 _1053_
+ sky130_fd_sc_hd__nand3_1
XFILLER_0_1_220 vssd1 vssd1 vccd1 vccd1 sky130_fd_sc_hd__decap_4
X_4403_ clknet_leaf_3_clk _0214_ vssd1 vssd1 vccd1 vccd1 u_core.u_regfile.rf\[29\]\[7\]
+ sky130_fd_sc_hd__dfxtp_1
XFILLER_0_22_381 vssd1 vssd1 vccd1 vccd1 sky130_fd_sc_hd__decap_3
X_4334_ clknet_leaf_3_clk _0145_ vssd1 vssd1 vccd1 vccd1 u_core.u_regfile.rf\[5\]\[2\]
+ sky130_fd_sc_hd__dfxtp_1
X_4265_ clknet_leaf_4_clk _0004_ net33 vssd1 vssd1 vccd1 vccd1 u_imem.addr\[3\] sky130_fd_sc_hd__dfrtp_4
X_3216_ _1609_ vssd1 vssd1 vccd1 vccd1 _0065_ sky130_fd_sc_hd__clkbuf_1
X_4196_ net315 vssd1 vssd1 vccd1 vccd1 _2098_ sky130_fd_sc_hd__clkbuf_1
X_3147_ _1567_ u_audio.counter\[1\] vssd1 vssd1 vccd1 vccd1 _1568_ sky130_fd_sc_hd__and2_1
XFILLER_0_82_83 vssd1 vssd1 vccd1 vccd1 sky130_fd_sc_hd__fill_1
X_3078_ u_timer.count_reg\[12\] u_timer.count_reg\[11\] u_timer.count_reg\[10\] _1518_
+ vssd1 vssd1 vccd1 vccd1 _1519_ sky130_fd_sc_hd__and4_1
XFILLER_0_37_407 vssd1 vssd1 vccd1 vccd1 sky130_fd_sc_hd__decap_6
XFILLER_0_9_320 vccd1 vssd1 vccd1 vssd1 sky130_ef_sc_hd__decap_12
XFILLER_0_9_353 vssd1 vssd1 vccd1 vccd1 sky130_fd_sc_hd__fill_1
XFILLER_0_64_237 vccd1 vssd1 vccd1 vssd1 sky130_ef_sc_hd__decap_12
XFILLER_0_60_421 vssd1 vssd1 vccd1 vccd1 sky130_fd_sc_hd__fill_2
XFILLER_0_32_134 vssd1 vssd1 vccd1 vccd1 sky130_fd_sc_hd__decap_6
Xhold271 u_core.u_regfile.rf\[24\]\[28\] vssd1 vssd1 vccd1 vccd1 net304 sky130_fd_sc_hd__dlygate4sd3_1
Xhold260 u_core.u_regfile.rf\[30\]\[11\] vssd1 vssd1 vccd1 vccd1 net293 sky130_fd_sc_hd__dlygate4sd3_1
Xhold293 u_core.u_regfile.rf\[2\]\[17\] vssd1 vssd1 vccd1 vccd1 net326 sky130_fd_sc_hd__dlygate4sd3_1
Xhold282 u_core.u_regfile.rf\[3\]\[22\] vssd1 vssd1 vccd1 vccd1 net315 sky130_fd_sc_hd__dlygate4sd3_1
XFILLER_0_28_429 vssd1 vssd1 vccd1 vccd1 sky130_fd_sc_hd__decap_8
XFILLER_0_70_207 vssd1 vssd1 vccd1 vccd1 sky130_fd_sc_hd__fill_2
XFILLER_0_11_35 vssd1 vssd1 vccd1 vccd1 sky130_fd_sc_hd__fill_1
XFILLER_0_63_281 vssd1 vssd1 vccd1 vccd1 sky130_fd_sc_hd__fill_1
XFILLER_0_11_79 vssd1 vssd1 vccd1 vccd1 sky130_fd_sc_hd__fill_1
XFILLER_0_23_167 vssd1 vssd1 vccd1 vccd1 sky130_fd_sc_hd__fill_1
X_2380_ _0743_ _0836_ _0837_ vssd1 vssd1 vccd1 vccd1 _0838_ sky130_fd_sc_hd__o21ai_2
X_4050_ net153 vssd1 vssd1 vccd1 vccd1 _2021_ sky130_fd_sc_hd__clkbuf_1
X_3001_ _0979_ vssd1 vssd1 vccd1 vccd1 _1459_ sky130_fd_sc_hd__inv_2
X_3903_ _1947_ vssd1 vssd1 vccd1 vccd1 _0414_ sky130_fd_sc_hd__clkbuf_1
X_3834_ net146 vssd1 vssd1 vccd1 vccd1 _1913_ sky130_fd_sc_hd__clkbuf_1
XFILLER_0_46_237 vssd1 vssd1 vccd1 vccd1 sky130_fd_sc_hd__fill_1
XFILLER_0_6_312 vssd1 vssd1 vccd1 vccd1 sky130_fd_sc_hd__fill_1
XFILLER_0_6_345 vccd1 vssd1 vccd1 vssd1 sky130_ef_sc_hd__decap_12
X_3765_ _1452_ _1451_ _1875_ _1878_ vssd1 vssd1 vccd1 vccd1 _0345_ sky130_fd_sc_hd__a31o_1
XFILLER_0_42_421 vssd1 vssd1 vccd1 vccd1 sky130_fd_sc_hd__decap_4
X_2716_ u_core.u_regfile.rf\[29\]\[16\] u_core.u_regfile.rf\[31\]\[16\] _0840_ vssd1
+ vssd1 vccd1 vccd1 _1174_ sky130_fd_sc_hd__mux2_1
X_3696_ _1840_ vssd1 vssd1 vccd1 vccd1 _0314_ sky130_fd_sc_hd__clkbuf_1
XFILLER_0_14_178 vssd1 vssd1 vccd1 vccd1 sky130_fd_sc_hd__fill_2
X_2647_ _1104_ _0710_ _0714_ _0909_ _0702_ vssd1 vssd1 vccd1 vccd1 _1105_ sky130_fd_sc_hd__a32o_1
X_2578_ _0922_ _0761_ u_core.u_regfile.rf\[6\]\[1\] vssd1 vssd1 vccd1 vccd1 _1036_
+ sky130_fd_sc_hd__o21bai_1
X_4317_ clknet_leaf_48_clk _0128_ vssd1 vssd1 vccd1 vccd1 u_core.u_regfile.rf\[4\]\[17\]
+ sky130_fd_sc_hd__dfxtp_1
XFILLER_0_10_395 vssd1 vssd1 vccd1 vccd1 sky130_fd_sc_hd__fill_1
X_4248_ clknet_leaf_32_clk _0063_ vssd1 vssd1 vccd1 vccd1 u_core.u_regfile.rf\[31\]\[16\]
+ sky130_fd_sc_hd__dfxtp_1
X_4179_ _2089_ vssd1 vssd1 vccd1 vccd1 _0548_ sky130_fd_sc_hd__clkbuf_1
XPHY_90 vssd1 vssd1 vccd1 vccd1 sky130_fd_sc_hd__decap_3
XFILLER_0_71_505 vssd1 vssd1 vccd1 vccd1 sky130_fd_sc_hd__decap_4
XFILLER_0_24_421 vssd1 vssd1 vccd1 vccd1 sky130_fd_sc_hd__fill_1
XFILLER_0_24_454 vssd1 vssd1 vccd1 vccd1 sky130_fd_sc_hd__decap_4
X_3550_ net409 vssd1 vssd1 vccd1 vccd1 _1780_ sky130_fd_sc_hd__clkbuf_1
X_2501_ _0938_ u_core.u_regfile.rf\[7\]\[8\] _0802_ vssd1 vssd1 vccd1 vccd1 _0959_
+ sky130_fd_sc_hd__nand3_1
XFILLER_0_3_337 vccd1 vssd1 vccd1 vssd1 sky130_ef_sc_hd__decap_12
X_3481_ _1731_ _1725_ _1739_ _1726_ _0673_ vssd1 vssd1 vccd1 vccd1 _1744_ sky130_fd_sc_hd__a41o_1
XFILLER_0_11_148 vccd1 vssd1 vccd1 vssd1 sky130_ef_sc_hd__decap_12
X_2432_ u_core.u_regfile.rf\[1\]\[12\] _0742_ _0731_ _0710_ vssd1 vssd1 vccd1 vccd1
+ _0890_ sky130_fd_sc_hd__o2bb2a_1
X_2363_ _0816_ _0820_ _0736_ vssd1 vssd1 vccd1 vccd1 _0821_ sky130_fd_sc_hd__and3b_1
XFILLER_0_47_53 vssd1 vssd1 vccd1 vccd1 sky130_fd_sc_hd__decap_3
X_4102_ net331 vssd1 vssd1 vccd1 vccd1 _2047_ sky130_fd_sc_hd__clkbuf_1
X_4033_ _2012_ vssd1 vssd1 vccd1 vccd1 _0479_ sky130_fd_sc_hd__clkbuf_1
X_2294_ u_imem.addr\[4\] vssd1 vssd1 vccd1 vccd1 _0752_ sky130_fd_sc_hd__inv_2
XFILLER_0_47_86 vssd1 vssd1 vccd1 vccd1 sky130_fd_sc_hd__decap_6
XFILLER_0_78_126 vssd1 vssd1 vccd1 vccd1 sky130_fd_sc_hd__decap_3
XFILLER_0_74_321 vssd1 vssd1 vccd1 vccd1 sky130_fd_sc_hd__decap_3
X_4797_ clknet_leaf_41_clk _0565_ vssd1 vssd1 vccd1 vccd1 u_core.u_regfile.rf\[3\]\[30\]
+ sky130_fd_sc_hd__dfxtp_1
X_3817_ _1904_ vssd1 vssd1 vccd1 vccd1 _0371_ sky130_fd_sc_hd__clkbuf_1
X_3748_ _1861_ _1434_ _1867_ vssd1 vssd1 vccd1 vccd1 _0339_ sky130_fd_sc_hd__o21ai_1
XFILLER_0_6_197 vssd1 vssd1 vccd1 vccd1 sky130_fd_sc_hd__decap_6
XFILLER_0_42_251 vssd1 vssd1 vccd1 vccd1 sky130_fd_sc_hd__fill_1
X_3679_ net204 vssd1 vssd1 vccd1 vccd1 _1832_ sky130_fd_sc_hd__clkbuf_1
XFILLER_0_69_148 vssd1 vssd1 vccd1 vccd1 sky130_fd_sc_hd__decap_4
Xclkbuf_leaf_50_clk clknet_2_0__leaf_clk vssd1 vssd1 vccd1 vccd1 clknet_leaf_50_clk
+ sky130_fd_sc_hd__clkbuf_16
XTAP_608 vssd1 vccd1 sky130_fd_sc_hd__tapvpwrvgnd_1
XTAP_619 vssd1 vccd1 sky130_fd_sc_hd__tapvpwrvgnd_1
XFILLER_0_84_29 vccd1 vssd1 vccd1 vssd1 sky130_ef_sc_hd__decap_12
XFILLER_0_33_11 vssd1 vssd1 vccd1 vccd1 sky130_fd_sc_hd__decap_3
X_2981_ _1073_ _1102_ _1138_ vssd1 vssd1 vccd1 vccd1 _1439_ sky130_fd_sc_hd__a21o_1
Xclkbuf_leaf_41_clk clknet_2_1__leaf_clk vssd1 vssd1 vccd1 vccd1 clknet_leaf_41_clk
+ sky130_fd_sc_hd__clkbuf_16
X_4720_ clknet_leaf_33_clk _0521_ vssd1 vssd1 vccd1 vccd1 u_core.u_regfile.rf\[25\]\[26\]
+ sky130_fd_sc_hd__dfxtp_1
X_4651_ clknet_leaf_37_clk _0452_ vssd1 vssd1 vccd1 vccd1 u_core.u_regfile.rf\[26\]\[21\]
+ sky130_fd_sc_hd__dfxtp_1
XFILLER_0_71_335 vssd1 vssd1 vccd1 vccd1 sky130_fd_sc_hd__fill_1
X_3602_ _1794_ _1795_ _1796_ net77 vssd1 vssd1 vccd1 vccd1 _0264_ sky130_fd_sc_hd__o31a_1
X_4582_ clknet_leaf_34_clk _0383_ vssd1 vssd1 vccd1 vccd1 u_core.u_regfile.rf\[27\]\[16\]
+ sky130_fd_sc_hd__dfxtp_1
X_3533_ _1771_ vssd1 vssd1 vccd1 vccd1 _0220_ sky130_fd_sc_hd__clkbuf_1
X_3464_ _1731_ _1725_ _1714_ _1726_ _0667_ vssd1 vssd1 vccd1 vccd1 _1732_ sky130_fd_sc_hd__a41o_1
XFILLER_0_12_457 vssd1 vssd1 vccd1 vccd1 sky130_fd_sc_hd__fill_2
X_2415_ _0871_ _0872_ vssd1 vssd1 vccd1 vccd1 _0873_ sky130_fd_sc_hd__nand2_1
XFILLER_0_58_41 vssd1 vssd1 vccd1 vccd1 sky130_fd_sc_hd__fill_2
X_3395_ _1332_ _1678_ _1479_ _1412_ vssd1 vssd1 vccd1 vccd1 _1679_ sky130_fd_sc_hd__nand4_2
X_2346_ _0801_ _0711_ _0803_ vssd1 vssd1 vccd1 vccd1 _0804_ sky130_fd_sc_hd__and3_1
X_2277_ _0734_ vssd1 vssd1 vccd1 vccd1 _0735_ sky130_fd_sc_hd__buf_4
X_4016_ net189 vssd1 vssd1 vccd1 vccd1 _2004_ sky130_fd_sc_hd__clkbuf_1
XFILLER_0_28_3 vccd1 vssd1 vccd1 vssd1 sky130_ef_sc_hd__decap_12
XFILLER_0_79_479 vccd1 vssd1 vccd1 vssd1 sky130_ef_sc_hd__decap_12
XFILLER_0_47_321 vssd1 vssd1 vccd1 vccd1 sky130_fd_sc_hd__decap_8
XFILLER_0_35_505 vssd1 vssd1 vccd1 vccd1 sky130_fd_sc_hd__decap_4
Xclkbuf_leaf_32_clk clknet_2_1__leaf_clk vssd1 vssd1 vccd1 vccd1 clknet_leaf_32_clk
+ sky130_fd_sc_hd__clkbuf_16
XFILLER_0_85_405 vccd1 vssd1 vccd1 vssd1 sky130_ef_sc_hd__decap_12
XFILLER_0_85_449 vccd1 vssd1 vccd1 vssd1 sky130_ef_sc_hd__decap_12
Xclkbuf_leaf_23_clk clknet_2_3__leaf_clk vssd1 vssd1 vccd1 vccd1 clknet_leaf_23_clk
+ sky130_fd_sc_hd__clkbuf_16
XFILLER_0_65_184 vccd1 vssd1 vccd1 vssd1 sky130_ef_sc_hd__decap_12
XFILLER_0_80_176 vccd1 vssd1 vccd1 vssd1 sky130_ef_sc_hd__decap_12
XFILLER_0_41_508 vssd1 vssd1 vccd1 vccd1 sky130_fd_sc_hd__fill_2
XFILLER_0_0_137 vssd1 vssd1 vccd1 vccd1 sky130_fd_sc_hd__decap_3
XTAP_405 vssd1 vccd1 sky130_fd_sc_hd__tapvpwrvgnd_1
X_2200_ _0615_ _0654_ _0619_ _0658_ vssd1 vssd1 vccd1 vccd1 _0659_ sky130_fd_sc_hd__o22a_1
XTAP_416 vssd1 vccd1 sky130_fd_sc_hd__tapvpwrvgnd_1
XTAP_427 vssd1 vccd1 sky130_fd_sc_hd__tapvpwrvgnd_1
XTAP_438 vssd1 vccd1 sky130_fd_sc_hd__tapvpwrvgnd_1
XTAP_449 vssd1 vccd1 sky130_fd_sc_hd__tapvpwrvgnd_1
X_3180_ _1591_ vssd1 vssd1 vccd1 vccd1 _0047_ sky130_fd_sc_hd__clkbuf_1
X_2131_ u_timer.count_reg\[27\] _0588_ u_timer.count_reg\[26\] _0589_ vssd1 vssd1
+ vccd1 vccd1 _0590_ sky130_fd_sc_hd__o22a_1
XFILLER_0_44_76 vssd1 vssd1 vccd1 vccd1 sky130_fd_sc_hd__decap_8
XFILLER_0_69_490 vccd1 vssd1 vccd1 vssd1 sky130_ef_sc_hd__decap_12
XFILLER_0_17_505 vssd1 vssd1 vccd1 vccd1 sky130_fd_sc_hd__decap_4
XFILLER_0_29_343 vssd1 vssd1 vccd1 vccd1 sky130_fd_sc_hd__decap_6
X_2964_ net18 _1114_ _1420_ vssd1 vssd1 vccd1 vccd1 _1422_ sky130_fd_sc_hd__o21ai_2
Xclkbuf_leaf_14_clk clknet_2_2__leaf_clk vssd1 vssd1 vccd1 vccd1 clknet_leaf_14_clk
+ sky130_fd_sc_hd__clkbuf_16
X_4703_ clknet_leaf_38_clk _0504_ vssd1 vssd1 vccd1 vccd1 u_core.u_regfile.rf\[25\]\[9\]
+ sky130_fd_sc_hd__dfxtp_1
XFILLER_0_56_162 vssd1 vssd1 vccd1 vccd1 sky130_fd_sc_hd__decap_4
X_2895_ _1008_ _1152_ _1178_ vssd1 vssd1 vccd1 vccd1 _1353_ sky130_fd_sc_hd__o21ai_2
XFILLER_0_60_97 vssd1 vssd1 vccd1 vccd1 sky130_fd_sc_hd__decap_4
XFILLER_0_4_421 vccd1 vssd1 vccd1 vssd1 sky130_ef_sc_hd__decap_12
X_4634_ clknet_leaf_24_clk _0435_ vssd1 vssd1 vccd1 vccd1 u_core.u_regfile.rf\[26\]\[4\]
+ sky130_fd_sc_hd__dfxtp_1
X_4565_ clknet_leaf_6_clk _0366_ vssd1 vssd1 vccd1 vccd1 u_core.u_regfile.rf\[28\]\[31\]
+ sky130_fd_sc_hd__dfxtp_1
XFILLER_0_12_243 vssd1 vssd1 vccd1 vccd1 sky130_fd_sc_hd__fill_1
X_3516_ net444 vssd1 vssd1 vccd1 vccd1 _1763_ sky130_fd_sc_hd__clkbuf_1
X_4496_ clknet_leaf_27_clk _0297_ vssd1 vssd1 vccd1 vccd1 u_core.u_regfile.rf\[30\]\[26\]
+ sky130_fd_sc_hd__dfxtp_1
XFILLER_0_12_298 vssd1 vssd1 vccd1 vccd1 sky130_fd_sc_hd__fill_1
X_3447_ _0993_ _0994_ _0995_ vssd1 vssd1 vccd1 vccd1 _1720_ sky130_fd_sc_hd__a21o_1
XTAP_961 vssd1 vccd1 sky130_fd_sc_hd__tapvpwrvgnd_1
XTAP_950 vssd1 vccd1 sky130_fd_sc_hd__tapvpwrvgnd_1
X_3378_ _1671_ _1672_ _1673_ net80 vssd1 vssd1 vccd1 vccd1 _0163_ sky130_fd_sc_hd__o31a_1
X_2329_ _0717_ _0741_ u_core.u_regfile.rf\[1\]\[28\] _0743_ _0786_ vssd1 vssd1 vccd1
+ vccd1 _0787_ sky130_fd_sc_hd__a221o_2
XFILLER_0_79_221 vssd1 vssd1 vccd1 vccd1 sky130_fd_sc_hd__decap_3
XFILLER_0_79_265 vssd1 vssd1 vccd1 vccd1 sky130_fd_sc_hd__decap_6
XFILLER_0_67_405 vssd1 vssd1 vccd1 vccd1 sky130_fd_sc_hd__decap_4
XFILLER_0_39_118 vccd1 vssd1 vccd1 vssd1 sky130_ef_sc_hd__decap_12
XFILLER_0_67_449 vssd1 vssd1 vccd1 vccd1 sky130_fd_sc_hd__decap_6
XFILLER_0_82_419 vssd1 vssd1 vccd1 vccd1 sky130_fd_sc_hd__fill_1
XFILLER_0_35_313 vssd1 vssd1 vccd1 vccd1 sky130_fd_sc_hd__fill_2
XFILLER_0_47_173 vssd1 vssd1 vccd1 vccd1 sky130_fd_sc_hd__fill_1
XFILLER_0_35_335 vssd1 vssd1 vccd1 vccd1 sky130_fd_sc_hd__fill_1
XFILLER_0_81_441 vssd1 vssd1 vccd1 vccd1 sky130_fd_sc_hd__decap_6
XFILLER_0_26_324 vssd1 vssd1 vccd1 vccd1 sky130_fd_sc_hd__decap_4
XFILLER_0_66_493 vssd1 vssd1 vccd1 vccd1 sky130_fd_sc_hd__fill_1
XFILLER_0_14_508 vssd1 vssd1 vccd1 vccd1 sky130_fd_sc_hd__fill_2
XFILLER_0_26_368 vssd1 vssd1 vccd1 vccd1 sky130_fd_sc_hd__decap_4
XFILLER_0_30_45 vssd1 vssd1 vccd1 vccd1 sky130_fd_sc_hd__decap_4
X_2680_ _1101_ _1137_ _1086_ vssd1 vssd1 vccd1 vccd1 _1138_ sky130_fd_sc_hd__o21ai_2
XFILLER_0_81_485 vccd1 vssd1 vccd1 vssd1 sky130_ef_sc_hd__decap_12
XFILLER_0_41_349 vssd1 vssd1 vccd1 vccd1 sky130_fd_sc_hd__fill_1
X_4350_ clknet_leaf_32_clk _0161_ vssd1 vssd1 vccd1 vccd1 u_core.u_regfile.rf\[5\]\[18\]
+ sky130_fd_sc_hd__dfxtp_1
X_3301_ _1641_ vssd1 vssd1 vccd1 vccd1 _0118_ sky130_fd_sc_hd__clkbuf_1
X_4281_ clknet_leaf_47_clk _0092_ vssd1 vssd1 vccd1 vccd1 u_core.u_regfile.rf\[6\]\[13\]
+ sky130_fd_sc_hd__dfxtp_1
XTAP_202 vssd1 vccd1 sky130_fd_sc_hd__tapvpwrvgnd_1
XTAP_213 vssd1 vccd1 sky130_fd_sc_hd__tapvpwrvgnd_1
XTAP_224 vssd1 vccd1 sky130_fd_sc_hd__tapvpwrvgnd_1
XTAP_257 vssd1 vccd1 sky130_fd_sc_hd__tapvpwrvgnd_1
XTAP_246 vssd1 vccd1 sky130_fd_sc_hd__tapvpwrvgnd_1
XTAP_235 vssd1 vccd1 sky130_fd_sc_hd__tapvpwrvgnd_1
Xclkbuf_leaf_3_clk clknet_2_0__leaf_clk vssd1 vssd1 vccd1 vccd1 clknet_leaf_3_clk
+ sky130_fd_sc_hd__clkbuf_16
X_3232_ _1617_ vssd1 vssd1 vccd1 vccd1 _0073_ sky130_fd_sc_hd__clkbuf_1
X_3163_ net34 vssd1 vssd1 vccd1 vccd1 _0039_ sky130_fd_sc_hd__inv_2
XTAP_279 vssd1 vccd1 sky130_fd_sc_hd__tapvpwrvgnd_1
XTAP_268 vssd1 vccd1 sky130_fd_sc_hd__tapvpwrvgnd_1
X_3094_ _1490_ _1529_ _1530_ vssd1 vssd1 vccd1 vccd1 _1531_ sky130_fd_sc_hd__and3_1
XFILLER_0_76_235 vssd1 vssd1 vccd1 vccd1 sky130_fd_sc_hd__fill_2
Xfanout28 net32 vssd1 vssd1 vccd1 vccd1 net28 sky130_fd_sc_hd__clkbuf_4
X_3996_ net264 vssd1 vssd1 vccd1 vccd1 _1994_ sky130_fd_sc_hd__clkbuf_1
XFILLER_0_84_290 vccd1 vssd1 vccd1 vssd1 sky130_ef_sc_hd__decap_12
X_2947_ _0717_ vssd1 vssd1 vccd1 vccd1 _1405_ sky130_fd_sc_hd__buf_4
XFILLER_0_32_349 vssd1 vssd1 vccd1 vccd1 sky130_fd_sc_hd__fill_1
X_4617_ clknet_leaf_26_clk _0418_ vssd1 vssd1 vccd1 vccd1 u_core.u_regfile.rf\[1\]\[19\]
+ sky130_fd_sc_hd__dfxtp_1
X_2878_ _1294_ net16 _0847_ _1335_ vssd1 vssd1 vccd1 vccd1 _1336_ sky130_fd_sc_hd__o22ai_4
Xhold420 u_core.u_regfile.rf\[4\]\[27\] vssd1 vssd1 vccd1 vccd1 net453 sky130_fd_sc_hd__dlygate4sd3_1
Xhold442 u_timer.threshold_reg\[7\] vssd1 vssd1 vccd1 vccd1 net475 sky130_fd_sc_hd__dlygate4sd3_1
X_4548_ clknet_leaf_43_clk _0349_ vssd1 vssd1 vccd1 vccd1 u_core.u_regfile.rf\[28\]\[14\]
+ sky130_fd_sc_hd__dfxtp_1
Xhold431 u_core.u_regfile.rf\[28\]\[16\] vssd1 vssd1 vccd1 vccd1 net464 sky130_fd_sc_hd__dlygate4sd3_1
Xhold453 u_core.u_regfile.rf\[28\]\[20\] vssd1 vssd1 vccd1 vccd1 net486 sky130_fd_sc_hd__dlygate4sd3_1
X_4479_ clknet_leaf_36_clk _0280_ vssd1 vssd1 vccd1 vccd1 u_core.u_regfile.rf\[30\]\[9\]
+ sky130_fd_sc_hd__dfxtp_1
Xhold475 u_audio.counter\[7\] vssd1 vssd1 vccd1 vccd1 net508 sky130_fd_sc_hd__dlygate4sd3_1
Xhold486 u_core.u_regfile.rf\[28\]\[26\] vssd1 vssd1 vccd1 vccd1 net519 sky130_fd_sc_hd__dlygate4sd3_1
Xhold464 net9 vssd1 vssd1 vccd1 vccd1 net497 sky130_fd_sc_hd__dlygate4sd3_1
Xhold497 u_core.u_regfile.rf\[31\]\[13\] vssd1 vssd1 vccd1 vccd1 net530 sky130_fd_sc_hd__dlygate4sd3_1
XTAP_780 vssd1 vccd1 sky130_fd_sc_hd__tapvpwrvgnd_1
XTAP_791 vssd1 vccd1 sky130_fd_sc_hd__tapvpwrvgnd_1
XFILLER_0_67_279 vssd1 vssd1 vccd1 vccd1 sky130_fd_sc_hd__fill_1
XFILLER_0_35_110 vssd1 vssd1 vccd1 vccd1 sky130_fd_sc_hd__fill_2
XFILLER_0_35_132 vssd1 vssd1 vccd1 vccd1 sky130_fd_sc_hd__fill_2
XFILLER_0_63_485 vssd1 vssd1 vccd1 vccd1 sky130_fd_sc_hd__fill_1
XFILLER_0_31_393 vccd1 vssd1 vccd1 vssd1 sky130_ef_sc_hd__decap_12
XFILLER_0_46_408 vccd1 vssd1 vccd1 vssd1 sky130_ef_sc_hd__decap_12
X_3850_ net210 vssd1 vssd1 vccd1 vccd1 _1921_ sky130_fd_sc_hd__clkbuf_1
XFILLER_0_58_268 vccd1 vssd1 vccd1 vssd1 sky130_ef_sc_hd__decap_12
XFILLER_0_6_505 vssd1 vssd1 vccd1 vccd1 sky130_fd_sc_hd__decap_4
X_2801_ _0744_ _0747_ _0750_ u_core.u_regfile.rf\[4\]\[22\] vssd1 vssd1 vccd1 vccd1
+ _1259_ sky130_fd_sc_hd__o22a_1
X_3781_ net67 _1861_ _1886_ vssd1 vssd1 vccd1 vccd1 _0353_ sky130_fd_sc_hd__a21o_1
XFILLER_0_54_430 vssd1 vssd1 vccd1 vccd1 sky130_fd_sc_hd__fill_2
X_2732_ _1185_ _0965_ _1189_ vssd1 vssd1 vccd1 vccd1 _1190_ sky130_fd_sc_hd__a21oi_2
XFILLER_0_54_452 vccd1 vssd1 vccd1 vssd1 sky130_ef_sc_hd__decap_12
XFILLER_0_14_327 vssd1 vssd1 vccd1 vccd1 sky130_fd_sc_hd__fill_1
X_2663_ _0860_ u_core.u_regfile.rf\[7\]\[7\] _0861_ vssd1 vssd1 vccd1 vccd1 _1121_
+ sky130_fd_sc_hd__nand3_1
X_2594_ _0866_ u_core.u_regfile.rf\[1\]\[2\] _0857_ _0867_ vssd1 vssd1 vccd1 vccd1
+ _1052_ sky130_fd_sc_hd__a31o_1
X_4402_ clknet_leaf_8_clk _0213_ vssd1 vssd1 vccd1 vccd1 u_core.u_regfile.rf\[29\]\[6\]
+ sky130_fd_sc_hd__dfxtp_1
X_4333_ clknet_leaf_4_clk _0144_ vssd1 vssd1 vccd1 vccd1 u_core.u_regfile.rf\[5\]\[1\]
+ sky130_fd_sc_hd__dfxtp_1
X_4264_ clknet_leaf_4_clk _0003_ net33 vssd1 vssd1 vccd1 vccd1 u_imem.addr\[2\] sky130_fd_sc_hd__dfrtp_1
X_3215_ net500 vssd1 vssd1 vccd1 vccd1 _1609_ sky130_fd_sc_hd__clkbuf_1
X_4195_ _2097_ vssd1 vssd1 vccd1 vccd1 _0556_ sky130_fd_sc_hd__clkbuf_1
XFILLER_0_66_85 vssd1 vssd1 vccd1 vccd1 sky130_fd_sc_hd__fill_2
X_3146_ net462 vssd1 vssd1 vccd1 vccd1 _1567_ sky130_fd_sc_hd__inv_2
X_3077_ u_timer.count_reg\[9\] u_timer.count_reg\[8\] u_timer.count_reg\[7\] _1502_
+ vssd1 vssd1 vccd1 vccd1 _1518_ sky130_fd_sc_hd__and4_1
XFILLER_0_10_3 vccd1 vssd1 vccd1 vssd1 sky130_ef_sc_hd__decap_12
XFILLER_0_49_213 vssd1 vssd1 vccd1 vccd1 sky130_fd_sc_hd__fill_1
XFILLER_0_49_235 vssd1 vssd1 vccd1 vccd1 sky130_fd_sc_hd__fill_1
XFILLER_0_9_332 vssd1 vssd1 vccd1 vccd1 sky130_fd_sc_hd__fill_1
XFILLER_0_64_249 vssd1 vssd1 vccd1 vccd1 sky130_fd_sc_hd__decap_3
X_3979_ _1985_ vssd1 vssd1 vccd1 vccd1 _0452_ sky130_fd_sc_hd__clkbuf_1
XFILLER_0_45_452 vssd1 vssd1 vccd1 vccd1 sky130_fd_sc_hd__fill_1
XFILLER_0_45_474 vssd1 vssd1 vccd1 vccd1 sky130_fd_sc_hd__fill_1
XFILLER_0_32_168 vccd1 vssd1 vccd1 vssd1 sky130_ef_sc_hd__decap_12
XFILLER_0_60_477 vssd1 vssd1 vccd1 vccd1 sky130_fd_sc_hd__fill_1
Xhold261 u_core.u_regfile.rf\[25\]\[10\] vssd1 vssd1 vccd1 vccd1 net294 sky130_fd_sc_hd__dlygate4sd3_1
Xhold250 u_core.u_regfile.rf\[3\]\[10\] vssd1 vssd1 vccd1 vccd1 net283 sky130_fd_sc_hd__dlygate4sd3_1
Xhold283 u_core.u_regfile.rf\[27\]\[25\] vssd1 vssd1 vccd1 vccd1 net316 sky130_fd_sc_hd__dlygate4sd3_1
Xhold294 u_core.u_regfile.rf\[25\]\[7\] vssd1 vssd1 vccd1 vccd1 net327 sky130_fd_sc_hd__dlygate4sd3_1
Xhold272 u_core.u_regfile.rf\[2\]\[18\] vssd1 vssd1 vccd1 vccd1 net305 sky130_fd_sc_hd__dlygate4sd3_1
XFILLER_0_68_500 vssd1 vssd1 vccd1 vccd1 sky130_fd_sc_hd__decap_8
XFILLER_0_83_503 vssd1 vssd1 vccd1 vccd1 sky130_fd_sc_hd__fill_1
XFILLER_0_36_474 vssd1 vssd1 vccd1 vccd1 sky130_fd_sc_hd__fill_2
XFILLER_0_51_422 vssd1 vssd1 vccd1 vccd1 sky130_fd_sc_hd__decap_8
XFILLER_0_51_499 vssd1 vssd1 vccd1 vccd1 sky130_fd_sc_hd__decap_4
XFILLER_0_36_11 vssd1 vssd1 vccd1 vccd1 sky130_fd_sc_hd__fill_1
X_3000_ _0999_ _0997_ _1452_ _0979_ vssd1 vssd1 vccd1 vccd1 _1458_ sky130_fd_sc_hd__o211ai_4
X_3902_ net382 vssd1 vssd1 vccd1 vccd1 _1947_ sky130_fd_sc_hd__clkbuf_1
XFILLER_0_46_205 vssd1 vssd1 vccd1 vccd1 sky130_fd_sc_hd__fill_2
X_3833_ _1912_ vssd1 vssd1 vccd1 vccd1 _0379_ sky130_fd_sc_hd__clkbuf_1
XFILLER_0_27_441 vssd1 vssd1 vccd1 vccd1 sky130_fd_sc_hd__decap_6
XFILLER_0_6_357 vssd1 vssd1 vccd1 vccd1 sky130_fd_sc_hd__decap_6
X_3764_ _1876_ _1877_ net448 vssd1 vssd1 vccd1 vccd1 _1878_ sky130_fd_sc_hd__o21a_1
XFILLER_0_54_260 vssd1 vssd1 vccd1 vccd1 sky130_fd_sc_hd__decap_8
X_2715_ _1167_ _1171_ _0734_ _1172_ vssd1 vssd1 vccd1 vccd1 _1173_ sky130_fd_sc_hd__o211a_1
X_3695_ net168 vssd1 vssd1 vccd1 vccd1 _1840_ sky130_fd_sc_hd__clkbuf_1
XFILLER_0_54_293 vccd1 vssd1 vccd1 vssd1 sky130_ef_sc_hd__decap_12
XFILLER_0_14_168 vssd1 vssd1 vccd1 vccd1 sky130_fd_sc_hd__fill_2
X_2646_ u_core.u_regfile.rf\[29\]\[6\] u_core.u_regfile.rf\[31\]\[6\] _0840_ vssd1
+ vssd1 vccd1 vccd1 _1104_ sky130_fd_sc_hd__mux2_1
XFILLER_0_77_51 vssd1 vssd1 vccd1 vccd1 sky130_fd_sc_hd__decap_4
X_2577_ u_core.u_regfile.rf\[4\]\[1\] _0750_ _0812_ vssd1 vssd1 vccd1 vccd1 _1035_
+ sky130_fd_sc_hd__o21ai_2
XFILLER_0_58_3 vccd1 vssd1 vccd1 vssd1 sky130_ef_sc_hd__decap_12
X_4316_ clknet_leaf_48_clk _0127_ vssd1 vssd1 vccd1 vccd1 u_core.u_regfile.rf\[4\]\[16\]
+ sky130_fd_sc_hd__dfxtp_1
X_4247_ clknet_leaf_31_clk _0062_ vssd1 vssd1 vccd1 vccd1 u_core.u_regfile.rf\[31\]\[15\]
+ sky130_fd_sc_hd__dfxtp_1
X_4178_ net181 vssd1 vssd1 vccd1 vccd1 _2089_ sky130_fd_sc_hd__clkbuf_1
X_3129_ _1554_ vssd1 vssd1 vccd1 vccd1 _0026_ sky130_fd_sc_hd__clkbuf_1
XFILLER_0_65_503 vssd1 vssd1 vccd1 vccd1 sky130_fd_sc_hd__fill_1
XFILLER_0_18_452 vssd1 vssd1 vccd1 vccd1 sky130_fd_sc_hd__decap_3
XFILLER_0_18_474 vssd1 vssd1 vccd1 vccd1 sky130_fd_sc_hd__fill_2
XFILLER_0_60_241 vssd1 vssd1 vccd1 vccd1 sky130_fd_sc_hd__fill_2
XFILLER_0_20_105 vssd1 vssd1 vccd1 vccd1 sky130_fd_sc_hd__decap_3
XFILLER_0_68_330 vssd1 vssd1 vccd1 vccd1 sky130_fd_sc_hd__fill_1
XFILLER_0_68_363 vssd1 vssd1 vccd1 vccd1 sky130_fd_sc_hd__fill_1
XPHY_80 vssd1 vssd1 vccd1 vccd1 sky130_fd_sc_hd__decap_3
XPHY_91 vssd1 vssd1 vccd1 vccd1 sky130_fd_sc_hd__decap_3
XFILLER_0_43_208 vssd1 vssd1 vccd1 vccd1 sky130_fd_sc_hd__decap_3
XFILLER_0_3_305 vccd1 vssd1 vccd1 vssd1 sky130_ef_sc_hd__decap_12
X_2500_ u_core.u_regfile.rf\[6\]\[8\] vssd1 vssd1 vccd1 vccd1 _0958_ sky130_fd_sc_hd__inv_2
XFILLER_0_3_349 vccd1 vssd1 vccd1 vssd1 sky130_ef_sc_hd__decap_12
XFILLER_0_24_488 vssd1 vssd1 vccd1 vccd1 sky130_fd_sc_hd__fill_2
X_3480_ _1222_ _1741_ _1743_ vssd1 vssd1 vccd1 vccd1 _0195_ sky130_fd_sc_hd__o21ai_1
X_2431_ _0744_ _0748_ _0885_ u_core.u_regfile.rf\[4\]\[12\] _0888_ vssd1 vssd1 vccd1
+ vccd1 _0889_ sky130_fd_sc_hd__o221ai_4
X_2362_ _0772_ _0774_ _0694_ u_core.u_regfile.rf\[5\]\[26\] _0819_ vssd1 vssd1 vccd1
+ vccd1 _0820_ sky130_fd_sc_hd__o221a_1
X_2293_ _0750_ vssd1 vssd1 vccd1 vccd1 _0751_ sky130_fd_sc_hd__clkbuf_4
X_4101_ _2046_ vssd1 vssd1 vccd1 vccd1 _0513_ sky130_fd_sc_hd__clkbuf_1
X_4032_ net187 vssd1 vssd1 vccd1 vccd1 _2012_ sky130_fd_sc_hd__clkbuf_1
XFILLER_0_47_503 vssd1 vssd1 vccd1 vccd1 sky130_fd_sc_hd__fill_1
X_3816_ net356 vssd1 vssd1 vccd1 vccd1 _1904_ sky130_fd_sc_hd__clkbuf_1
X_4796_ clknet_leaf_38_clk _0564_ vssd1 vssd1 vccd1 vccd1 u_core.u_regfile.rf\[3\]\[29\]
+ sky130_fd_sc_hd__dfxtp_1
X_3747_ _1674_ _1862_ net59 vssd1 vssd1 vccd1 vccd1 _1867_ sky130_fd_sc_hd__o21ai_1
X_3678_ _1831_ vssd1 vssd1 vccd1 vccd1 _0305_ sky130_fd_sc_hd__clkbuf_1
X_2629_ _0965_ _1085_ _1074_ _1079_ vssd1 vssd1 vccd1 vccd1 _1087_ sky130_fd_sc_hd__a31o_1
XFILLER_0_10_193 vssd1 vssd1 vccd1 vccd1 sky130_fd_sc_hd__decap_3
Xmax_cap14 _1349_ vssd1 vssd1 vccd1 vccd1 net14 sky130_fd_sc_hd__buf_1
XFILLER_0_69_138 vssd1 vssd1 vccd1 vccd1 sky130_fd_sc_hd__decap_3
XFILLER_0_77_193 vssd1 vssd1 vccd1 vccd1 sky130_fd_sc_hd__decap_4
XFILLER_0_65_322 vccd1 vssd1 vccd1 vssd1 sky130_ef_sc_hd__decap_12
XFILLER_0_65_366 vssd1 vssd1 vccd1 vccd1 sky130_fd_sc_hd__fill_1
XTAP_609 vssd1 vccd1 sky130_fd_sc_hd__tapvpwrvgnd_1
XFILLER_0_75_119 vssd1 vssd1 vccd1 vccd1 sky130_fd_sc_hd__fill_1
X_2980_ _1432_ _1434_ _1436_ _1437_ vssd1 vssd1 vccd1 vccd1 _1438_ sky130_fd_sc_hd__nand4_1
X_4650_ clknet_leaf_25_clk _0451_ vssd1 vssd1 vccd1 vccd1 u_core.u_regfile.rf\[26\]\[20\]
+ sky130_fd_sc_hd__dfxtp_1
X_3601_ _1794_ _1795_ _1796_ net114 vssd1 vssd1 vccd1 vccd1 _0263_ sky130_fd_sc_hd__o31a_1
XFILLER_0_24_241 vssd1 vssd1 vccd1 vccd1 sky130_fd_sc_hd__fill_2
X_4581_ clknet_leaf_27_clk _0382_ vssd1 vssd1 vccd1 vccd1 u_core.u_regfile.rf\[27\]\[15\]
+ sky130_fd_sc_hd__dfxtp_1
XFILLER_0_3_146 vccd1 vssd1 vccd1 vssd1 sky130_ef_sc_hd__decap_12
XFILLER_0_24_296 vssd1 vssd1 vccd1 vccd1 sky130_fd_sc_hd__decap_3
X_3532_ net438 vssd1 vssd1 vccd1 vccd1 _1771_ sky130_fd_sc_hd__clkbuf_1
X_3463_ _1332_ vssd1 vssd1 vccd1 vccd1 _1731_ sky130_fd_sc_hd__clkbuf_4
X_2414_ _0779_ _0859_ _0869_ _0856_ vssd1 vssd1 vccd1 vccd1 _0872_ sky130_fd_sc_hd__o31ai_2
X_3394_ _1470_ _1471_ _1444_ _1675_ _1677_ vssd1 vssd1 vccd1 vccd1 _1678_ sky130_fd_sc_hd__o2111a_4
X_2345_ _0802_ vssd1 vssd1 vccd1 vccd1 _0803_ sky130_fd_sc_hd__buf_4
XFILLER_0_74_41 vccd1 vssd1 vccd1 vssd1 sky130_ef_sc_hd__decap_12
X_2276_ _0731_ _0709_ _0720_ _0733_ vssd1 vssd1 vccd1 vccd1 _0734_ sky130_fd_sc_hd__a31o_4
XFILLER_0_74_85 vccd1 vssd1 vccd1 vssd1 sky130_ef_sc_hd__decap_12
X_4015_ _2003_ vssd1 vssd1 vccd1 vccd1 _0470_ sky130_fd_sc_hd__clkbuf_1
XFILLER_0_79_447 vssd1 vssd1 vccd1 vccd1 sky130_fd_sc_hd__fill_1
XFILLER_0_74_141 vssd1 vssd1 vccd1 vccd1 sky130_fd_sc_hd__fill_1
XFILLER_0_47_366 vccd1 vssd1 vccd1 vssd1 sky130_ef_sc_hd__decap_12
XFILLER_0_7_474 vssd1 vssd1 vccd1 vccd1 sky130_fd_sc_hd__fill_1
XFILLER_0_62_347 vssd1 vssd1 vccd1 vccd1 sky130_fd_sc_hd__fill_1
X_4779_ clknet_leaf_32_clk _0547_ vssd1 vssd1 vccd1 vccd1 u_core.u_regfile.rf\[3\]\[12\]
+ sky130_fd_sc_hd__dfxtp_1
XFILLER_0_70_380 vssd1 vssd1 vccd1 vccd1 sky130_fd_sc_hd__fill_1
XFILLER_0_85_417 vssd1 vssd1 vccd1 vccd1 sky130_fd_sc_hd__decap_3
XFILLER_0_53_347 vssd1 vssd1 vccd1 vccd1 sky130_fd_sc_hd__fill_1
XTAP_406 vssd1 vccd1 sky130_fd_sc_hd__tapvpwrvgnd_1
XTAP_417 vssd1 vccd1 sky130_fd_sc_hd__tapvpwrvgnd_1
XTAP_428 vssd1 vccd1 sky130_fd_sc_hd__tapvpwrvgnd_1
XTAP_439 vssd1 vccd1 sky130_fd_sc_hd__tapvpwrvgnd_1
X_2130_ u_timer.threshold_reg\[26\] vssd1 vssd1 vccd1 vccd1 _0589_ sky130_fd_sc_hd__inv_2
X_2963_ net18 _1114_ _1420_ vssd1 vssd1 vccd1 vccd1 _1421_ sky130_fd_sc_hd__or3_1
XFILLER_0_8_238 vssd1 vssd1 vccd1 vccd1 sky130_fd_sc_hd__fill_2
XFILLER_0_56_174 vssd1 vssd1 vccd1 vccd1 sky130_fd_sc_hd__decap_4
X_4702_ clknet_leaf_19_clk _0503_ vssd1 vssd1 vccd1 vccd1 u_core.u_regfile.rf\[25\]\[8\]
+ sky130_fd_sc_hd__dfxtp_1
X_2894_ _0781_ _1203_ _1350_ vssd1 vssd1 vccd1 vccd1 _1352_ sky130_fd_sc_hd__or3_1
XFILLER_0_4_433 vccd1 vssd1 vccd1 vssd1 sky130_ef_sc_hd__decap_12
X_4633_ clknet_leaf_25_clk _0434_ vssd1 vssd1 vccd1 vccd1 u_core.u_regfile.rf\[26\]\[3\]
+ sky130_fd_sc_hd__dfxtp_1
X_4564_ clknet_leaf_17_clk _0365_ vssd1 vssd1 vccd1 vccd1 u_core.u_regfile.rf\[28\]\[30\]
+ sky130_fd_sc_hd__dfxtp_1
XFILLER_0_4_477 vccd1 vssd1 vccd1 vssd1 sky130_ef_sc_hd__decap_12
X_3515_ _1762_ vssd1 vssd1 vccd1 vccd1 _0211_ sky130_fd_sc_hd__clkbuf_1
X_4495_ clknet_leaf_37_clk _0296_ vssd1 vssd1 vccd1 vccd1 u_core.u_regfile.rf\[30\]\[25\]
+ sky130_fd_sc_hd__dfxtp_1
X_3446_ _0974_ _1704_ _1719_ vssd1 vssd1 vccd1 vccd1 _0185_ sky130_fd_sc_hd__o21ai_1
XTAP_962 vssd1 vccd1 sky130_fd_sc_hd__tapvpwrvgnd_1
XTAP_951 vssd1 vccd1 sky130_fd_sc_hd__tapvpwrvgnd_1
XTAP_940 vssd1 vccd1 sky130_fd_sc_hd__tapvpwrvgnd_1
XFILLER_0_40_3 vccd1 vssd1 vccd1 vssd1 sky130_ef_sc_hd__decap_12
X_3377_ _0898_ vssd1 vssd1 vccd1 vccd1 _1673_ sky130_fd_sc_hd__clkbuf_4
X_2328_ _0746_ _0748_ _0751_ u_core.u_regfile.rf\[4\]\[28\] _0785_ vssd1 vssd1 vccd1
+ vccd1 _0786_ sky130_fd_sc_hd__o221a_1
X_2259_ _0716_ vssd1 vssd1 vccd1 vccd1 _0717_ sky130_fd_sc_hd__clkbuf_4
XFILLER_0_47_130 vssd1 vssd1 vccd1 vccd1 sky130_fd_sc_hd__fill_1
XFILLER_0_75_483 vccd1 vssd1 vccd1 vssd1 sky130_ef_sc_hd__decap_12
XFILLER_0_23_509 vssd1 vssd1 vccd1 vccd1 sky130_fd_sc_hd__fill_1
XFILLER_0_50_306 vssd1 vssd1 vccd1 vccd1 sky130_fd_sc_hd__fill_2
XFILLER_0_62_177 vssd1 vssd1 vccd1 vccd1 sky130_fd_sc_hd__fill_1
XFILLER_0_85_225 vssd1 vssd1 vccd1 vccd1 sky130_fd_sc_hd__decap_8
XFILLER_0_73_409 vssd1 vssd1 vccd1 vccd1 sky130_fd_sc_hd__fill_1
XFILLER_0_66_450 vssd1 vssd1 vccd1 vccd1 sky130_fd_sc_hd__decap_8
XFILLER_0_81_497 vssd1 vssd1 vccd1 vccd1 sky130_fd_sc_hd__decap_6
XFILLER_0_30_79 vssd1 vssd1 vccd1 vccd1 sky130_fd_sc_hd__decap_4
X_3300_ net417 vssd1 vssd1 vccd1 vccd1 _1641_ sky130_fd_sc_hd__clkbuf_1
XFILLER_0_1_447 vssd1 vssd1 vccd1 vccd1 sky130_fd_sc_hd__fill_1
X_4280_ clknet_leaf_47_clk _0091_ vssd1 vssd1 vccd1 vccd1 u_core.u_regfile.rf\[6\]\[12\]
+ sky130_fd_sc_hd__dfxtp_1
XTAP_203 vssd1 vccd1 sky130_fd_sc_hd__tapvpwrvgnd_1
XTAP_214 vssd1 vccd1 sky130_fd_sc_hd__tapvpwrvgnd_1
XFILLER_0_39_55 vssd1 vssd1 vccd1 vccd1 sky130_fd_sc_hd__fill_1
XTAP_247 vssd1 vccd1 sky130_fd_sc_hd__tapvpwrvgnd_1
XTAP_236 vssd1 vccd1 sky130_fd_sc_hd__tapvpwrvgnd_1
XTAP_225 vssd1 vccd1 sky130_fd_sc_hd__tapvpwrvgnd_1
X_3231_ net556 vssd1 vssd1 vccd1 vccd1 _1617_ sky130_fd_sc_hd__clkbuf_1
XTAP_269 vssd1 vccd1 sky130_fd_sc_hd__tapvpwrvgnd_1
XTAP_258 vssd1 vccd1 sky130_fd_sc_hd__tapvpwrvgnd_1
X_3162_ _1562_ net508 _1576_ _1581_ _1582_ vssd1 vssd1 vccd1 vccd1 _0000_ sky130_fd_sc_hd__a221oi_1
X_3093_ _0661_ _0614_ _0613_ _1522_ vssd1 vssd1 vccd1 vccd1 _1530_ sky130_fd_sc_hd__or4b_1
Xfanout29 net32 vssd1 vssd1 vccd1 vccd1 net29 sky130_fd_sc_hd__clkbuf_2
X_3995_ _1993_ vssd1 vssd1 vccd1 vccd1 _0460_ sky130_fd_sc_hd__clkbuf_1
X_2946_ _0768_ _1403_ _1301_ _0793_ vssd1 vssd1 vccd1 vccd1 _1404_ sky130_fd_sc_hd__o211ai_2
X_2877_ _1274_ _1293_ _1334_ vssd1 vssd1 vccd1 vccd1 _1335_ sky130_fd_sc_hd__a21oi_1
X_4616_ clknet_leaf_41_clk _0417_ vssd1 vssd1 vccd1 vccd1 u_core.u_regfile.rf\[1\]\[18\]
+ sky130_fd_sc_hd__dfxtp_1
Xhold410 u_core.u_regfile.rf\[29\]\[4\] vssd1 vssd1 vccd1 vccd1 net443 sky130_fd_sc_hd__dlygate4sd3_1
Xhold421 u_core.u_regfile.rf\[28\]\[11\] vssd1 vssd1 vccd1 vccd1 net454 sky130_fd_sc_hd__dlygate4sd3_1
X_4547_ clknet_leaf_30_clk _0348_ vssd1 vssd1 vccd1 vccd1 u_core.u_regfile.rf\[28\]\[13\]
+ sky130_fd_sc_hd__dfxtp_1
Xhold432 u_core.u_regfile.rf\[31\]\[3\] vssd1 vssd1 vccd1 vccd1 net465 sky130_fd_sc_hd__dlygate4sd3_1
Xhold454 u_core.u_regfile.rf\[31\]\[6\] vssd1 vssd1 vccd1 vccd1 net487 sky130_fd_sc_hd__dlygate4sd3_1
Xhold443 net10 vssd1 vssd1 vccd1 vccd1 net476 sky130_fd_sc_hd__dlygate4sd3_1
X_4478_ clknet_leaf_32_clk _0279_ vssd1 vssd1 vccd1 vccd1 u_core.u_regfile.rf\[30\]\[8\]
+ sky130_fd_sc_hd__dfxtp_1
Xhold476 u_core.u_regfile.rf\[28\]\[6\] vssd1 vssd1 vccd1 vccd1 net509 sky130_fd_sc_hd__dlygate4sd3_1
Xhold465 u_core.u_regfile.rf\[31\]\[1\] vssd1 vssd1 vccd1 vccd1 net498 sky130_fd_sc_hd__dlygate4sd3_1
Xhold487 u_audio.counter\[5\] vssd1 vssd1 vccd1 vccd1 net520 sky130_fd_sc_hd__dlygate4sd3_1
Xhold498 net6 vssd1 vssd1 vccd1 vccd1 net531 sky130_fd_sc_hd__dlygate4sd3_1
X_3429_ _1332_ vssd1 vssd1 vccd1 vccd1 _1705_ sky130_fd_sc_hd__clkbuf_4
XTAP_770 vssd1 vccd1 sky130_fd_sc_hd__tapvpwrvgnd_1
XTAP_781 vssd1 vccd1 sky130_fd_sc_hd__tapvpwrvgnd_1
XTAP_792 vssd1 vccd1 sky130_fd_sc_hd__tapvpwrvgnd_1
XFILLER_0_63_453 vssd1 vssd1 vccd1 vccd1 sky130_fd_sc_hd__fill_1
XFILLER_0_50_158 vssd1 vssd1 vccd1 vccd1 sky130_fd_sc_hd__decap_8
XFILLER_0_25_57 vssd1 vssd1 vccd1 vccd1 sky130_fd_sc_hd__fill_1
XFILLER_0_39_461 vssd1 vssd1 vccd1 vccd1 sky130_fd_sc_hd__decap_6
X_2800_ _0939_ _0938_ u_core.u_regfile.rf\[7\]\[22\] _0755_ vssd1 vssd1 vccd1 vccd1
+ _1258_ sky130_fd_sc_hd__a31o_1
XFILLER_0_41_34 vssd1 vssd1 vccd1 vccd1 sky130_fd_sc_hd__decap_6
X_3780_ _1206_ _1400_ _0783_ _1355_ vssd1 vssd1 vccd1 vccd1 _1886_ sky130_fd_sc_hd__o211a_1
X_2731_ _0952_ _0773_ _0693_ u_core.u_regfile.rf\[5\]\[18\] _1188_ vssd1 vssd1 vccd1
+ vccd1 _1189_ sky130_fd_sc_hd__o221a_1
XFILLER_0_54_464 vccd1 vssd1 vccd1 vssd1 sky130_ef_sc_hd__decap_12
XFILLER_0_14_306 vssd1 vssd1 vccd1 vccd1 sky130_fd_sc_hd__fill_2
X_2662_ u_core.u_regfile.rf\[6\]\[7\] vssd1 vssd1 vccd1 vccd1 _1120_ sky130_fd_sc_hd__inv_2
X_4401_ clknet_leaf_8_clk _0212_ vssd1 vssd1 vccd1 vccd1 u_core.u_regfile.rf\[29\]\[5\]
+ sky130_fd_sc_hd__dfxtp_1
X_2593_ u_core.u_regfile.rf\[31\]\[2\] _0726_ _0858_ _0808_ vssd1 vssd1 vccd1 vccd1
+ _1051_ sky130_fd_sc_hd__a2bb2o_2
XFILLER_0_41_169 vssd1 vssd1 vccd1 vccd1 sky130_fd_sc_hd__decap_8
X_4332_ clknet_leaf_5_clk _0143_ vssd1 vssd1 vccd1 vccd1 u_core.u_regfile.rf\[5\]\[0\]
+ sky130_fd_sc_hd__dfxtp_1
XFILLER_0_5_34 vssd1 vssd1 vccd1 vccd1 sky130_fd_sc_hd__fill_1
X_4263_ clknet_leaf_9_clk _0078_ vssd1 vssd1 vccd1 vccd1 u_core.u_regfile.rf\[31\]\[31\]
+ sky130_fd_sc_hd__dfxtp_1
X_3214_ _1608_ vssd1 vssd1 vccd1 vccd1 _0064_ sky130_fd_sc_hd__clkbuf_1
X_4194_ net182 vssd1 vssd1 vccd1 vccd1 _2097_ sky130_fd_sc_hd__clkbuf_1
X_3145_ net493 vssd1 vssd1 vccd1 vccd1 _1566_ sky130_fd_sc_hd__inv_2
XFILLER_0_82_41 vccd1 vssd1 vccd1 vssd1 sky130_ef_sc_hd__decap_12
X_3076_ _1517_ vssd1 vssd1 vccd1 vccd1 _0009_ sky130_fd_sc_hd__clkbuf_1
XFILLER_0_82_85 vccd1 vssd1 vccd1 vssd1 sky130_ef_sc_hd__decap_12
XFILLER_0_9_300 vssd1 vssd1 vccd1 vccd1 sky130_fd_sc_hd__fill_1
X_3978_ net206 vssd1 vssd1 vccd1 vccd1 _1985_ sky130_fd_sc_hd__clkbuf_1
XFILLER_0_17_133 vccd1 vssd1 vccd1 vssd1 sky130_ef_sc_hd__decap_12
XFILLER_0_9_388 vssd1 vssd1 vccd1 vccd1 sky130_fd_sc_hd__fill_1
X_2929_ _0807_ _0851_ vssd1 vssd1 vccd1 vccd1 _1387_ sky130_fd_sc_hd__and2_1
XFILLER_0_32_147 vssd1 vssd1 vccd1 vccd1 sky130_fd_sc_hd__fill_1
Xhold240 u_core.u_regfile.rf\[3\]\[18\] vssd1 vssd1 vccd1 vccd1 net273 sky130_fd_sc_hd__dlygate4sd3_1
Xhold262 u_core.u_regfile.rf\[3\]\[23\] vssd1 vssd1 vccd1 vccd1 net295 sky130_fd_sc_hd__dlygate4sd3_1
Xhold251 u_core.u_regfile.rf\[25\]\[3\] vssd1 vssd1 vccd1 vccd1 net284 sky130_fd_sc_hd__dlygate4sd3_1
Xhold273 u_core.u_regfile.rf\[27\]\[12\] vssd1 vssd1 vccd1 vccd1 net306 sky130_fd_sc_hd__dlygate4sd3_1
Xhold295 u_core.u_regfile.rf\[26\]\[23\] vssd1 vssd1 vccd1 vccd1 net328 sky130_fd_sc_hd__dlygate4sd3_1
Xhold284 u_core.u_regfile.rf\[26\]\[20\] vssd1 vssd1 vccd1 vccd1 net317 sky130_fd_sc_hd__dlygate4sd3_1
XFILLER_0_48_280 vssd1 vssd1 vccd1 vccd1 sky130_fd_sc_hd__fill_1
XFILLER_0_11_15 vccd1 vssd1 vccd1 vssd1 sky130_ef_sc_hd__decap_12
XFILLER_0_48_291 vssd1 vssd1 vccd1 vccd1 sky130_fd_sc_hd__decap_8
XFILLER_0_3_509 vssd1 vssd1 vccd1 vccd1 sky130_fd_sc_hd__fill_1
XFILLER_0_63_250 vccd1 vssd1 vccd1 vssd1 sky130_ef_sc_hd__decap_12
XFILLER_0_11_309 vssd1 vssd1 vccd1 vccd1 sky130_fd_sc_hd__fill_1
XFILLER_0_78_309 vssd1 vssd1 vccd1 vccd1 sky130_fd_sc_hd__decap_4
X_3901_ _1946_ vssd1 vssd1 vccd1 vccd1 _0413_ sky130_fd_sc_hd__clkbuf_1
X_3832_ net306 vssd1 vssd1 vccd1 vccd1 _1912_ sky130_fd_sc_hd__clkbuf_1
X_3763_ _0737_ vssd1 vssd1 vccd1 vccd1 _1877_ sky130_fd_sc_hd__clkbuf_4
X_2714_ u_core.u_regfile.rf\[31\]\[16\] _0895_ _0745_ _0803_ vssd1 vssd1 vccd1 vccd1
+ _1172_ sky130_fd_sc_hd__o22a_1
XFILLER_0_42_456 vssd1 vssd1 vccd1 vccd1 sky130_fd_sc_hd__fill_1
X_3694_ _1839_ vssd1 vssd1 vccd1 vccd1 _0313_ sky130_fd_sc_hd__clkbuf_1
X_2645_ _0808_ _0741_ u_core.u_regfile.rf\[28\]\[6\] vssd1 vssd1 vccd1 vccd1 _1103_
+ sky130_fd_sc_hd__o21a_1
X_4315_ clknet_leaf_40_clk _0126_ vssd1 vssd1 vccd1 vccd1 u_core.u_regfile.rf\[4\]\[15\]
+ sky130_fd_sc_hd__dfxtp_1
X_2576_ _1028_ _1033_ _0945_ vssd1 vssd1 vccd1 vccd1 _1034_ sky130_fd_sc_hd__nand3_1
X_4246_ clknet_leaf_44_clk _0061_ vssd1 vssd1 vccd1 vccd1 u_core.u_regfile.rf\[31\]\[14\]
+ sky130_fd_sc_hd__dfxtp_1
X_4177_ _2088_ vssd1 vssd1 vccd1 vccd1 _0547_ sky130_fd_sc_hd__clkbuf_1
X_3128_ _1552_ _0684_ _1553_ vssd1 vssd1 vccd1 vccd1 _1554_ sky130_fd_sc_hd__and3b_1
X_3059_ u_timer.count_reg\[7\] u_timer.count_reg\[6\] u_timer.count_reg\[5\] _1498_
+ vssd1 vssd1 vccd1 vccd1 _1505_ sky130_fd_sc_hd__and4_2
XFILLER_0_77_375 vccd1 vssd1 vccd1 vssd1 sky130_ef_sc_hd__decap_12
XFILLER_0_9_185 vssd1 vssd1 vccd1 vccd1 sky130_fd_sc_hd__fill_1
XFILLER_0_33_412 vccd1 vssd1 vccd1 vssd1 sky130_ef_sc_hd__decap_12
XFILLER_0_60_253 vssd1 vssd1 vccd1 vccd1 sky130_fd_sc_hd__fill_2
XPHY_70 vssd1 vssd1 vccd1 vccd1 sky130_fd_sc_hd__decap_3
XPHY_81 vssd1 vssd1 vccd1 vccd1 sky130_fd_sc_hd__decap_3
XPHY_92 vssd1 vssd1 vccd1 vccd1 sky130_fd_sc_hd__decap_3
XFILLER_0_22_69 vssd1 vssd1 vccd1 vccd1 sky130_fd_sc_hd__decap_6
XFILLER_0_24_401 vssd1 vssd1 vccd1 vccd1 sky130_fd_sc_hd__decap_4
XFILLER_0_3_317 vccd1 vssd1 vccd1 vssd1 sky130_ef_sc_hd__decap_12
X_2430_ _0886_ _0887_ _0750_ vssd1 vssd1 vccd1 vccd1 _0888_ sky130_fd_sc_hd__nand3_2
XFILLER_0_11_128 vssd1 vssd1 vccd1 vccd1 sky130_fd_sc_hd__fill_1
X_2361_ u_core.u_regfile.rf\[28\]\[26\] _0698_ _0701_ _0703_ _0818_ vssd1 vssd1 vccd1
+ vccd1 _0819_ sky130_fd_sc_hd__a221o_1
X_2292_ _0749_ vssd1 vssd1 vccd1 vccd1 _0750_ sky130_fd_sc_hd__clkbuf_4
X_4100_ net252 vssd1 vssd1 vccd1 vccd1 _2046_ sky130_fd_sc_hd__clkbuf_1
X_4031_ _2011_ vssd1 vssd1 vccd1 vccd1 _0478_ sky130_fd_sc_hd__clkbuf_1
XFILLER_0_47_66 vssd1 vssd1 vccd1 vccd1 sky130_fd_sc_hd__fill_1
XFILLER_0_59_331 vssd1 vssd1 vccd1 vccd1 sky130_fd_sc_hd__decap_4
XFILLER_0_63_65 vssd1 vssd1 vccd1 vccd1 sky130_fd_sc_hd__decap_8
XFILLER_0_59_386 vssd1 vssd1 vccd1 vccd1 sky130_fd_sc_hd__decap_3
X_4795_ clknet_leaf_22_clk _0563_ vssd1 vssd1 vccd1 vccd1 u_core.u_regfile.rf\[3\]\[28\]
+ sky130_fd_sc_hd__dfxtp_1
XFILLER_0_15_412 vssd1 vssd1 vccd1 vccd1 sky130_fd_sc_hd__decap_8
X_3815_ _1903_ vssd1 vssd1 vccd1 vccd1 _0370_ sky130_fd_sc_hd__clkbuf_1
XFILLER_0_15_445 vssd1 vssd1 vccd1 vccd1 sky130_fd_sc_hd__decap_3
X_3746_ _1861_ _1423_ _1866_ vssd1 vssd1 vccd1 vccd1 _0338_ sky130_fd_sc_hd__o21ai_1
XFILLER_0_30_437 vssd1 vssd1 vccd1 vccd1 sky130_fd_sc_hd__decap_8
XFILLER_0_42_286 vssd1 vssd1 vccd1 vccd1 sky130_fd_sc_hd__decap_8
X_3677_ net312 vssd1 vssd1 vccd1 vccd1 _1831_ sky130_fd_sc_hd__clkbuf_1
XFILLER_0_70_3 vccd1 vssd1 vccd1 vssd1 sky130_ef_sc_hd__decap_12
X_2628_ _1074_ _1079_ _1085_ _0735_ vssd1 vssd1 vccd1 vccd1 _1086_ sky130_fd_sc_hd__nand4_2
X_2559_ _0696_ u_core.u_regfile.rf\[28\]\[3\] _0702_ _0881_ vssd1 vssd1 vccd1 vccd1
+ _1017_ sky130_fd_sc_hd__a22oi_1
X_4229_ _1577_ _1481_ _2114_ vssd1 vssd1 vccd1 vccd1 _0573_ sky130_fd_sc_hd__a21oi_1
XFILLER_0_84_109 vssd1 vssd1 vccd1 vccd1 sky130_fd_sc_hd__decap_6
XFILLER_0_65_334 vssd1 vssd1 vccd1 vccd1 sky130_fd_sc_hd__fill_2
XFILLER_0_25_209 vssd1 vssd1 vccd1 vccd1 sky130_fd_sc_hd__decap_6
XFILLER_0_0_309 vccd1 vssd1 vccd1 vssd1 sky130_ef_sc_hd__decap_12
XFILLER_0_33_286 vssd1 vssd1 vccd1 vccd1 sky130_fd_sc_hd__decap_4
XFILLER_0_33_57 vssd1 vssd1 vccd1 vccd1 sky130_fd_sc_hd__fill_1
X_4580_ clknet_leaf_47_clk _0381_ vssd1 vssd1 vccd1 vccd1 u_core.u_regfile.rf\[27\]\[14\]
+ sky130_fd_sc_hd__dfxtp_1
X_3600_ _1794_ _1795_ _1796_ net69 vssd1 vssd1 vccd1 vccd1 _0262_ sky130_fd_sc_hd__o31a_1
X_3531_ _1770_ vssd1 vssd1 vccd1 vccd1 _0219_ sky130_fd_sc_hd__clkbuf_1
XFILLER_0_3_158 vssd1 vssd1 vccd1 vccd1 sky130_fd_sc_hd__decap_8
XFILLER_0_3_169 vssd1 vssd1 vccd1 vccd1 sky130_fd_sc_hd__decap_8
X_3462_ _1167_ _1171_ _1172_ vssd1 vssd1 vccd1 vccd1 _1730_ sky130_fd_sc_hd__o21ai_2
X_2413_ _0856_ _0870_ _0734_ vssd1 vssd1 vccd1 vccd1 _0871_ sky130_fd_sc_hd__nand3b_2
X_3393_ _1464_ _1465_ _1458_ _1461_ _1676_ vssd1 vssd1 vccd1 vccd1 _1677_ sky130_fd_sc_hd__a221oi_4
X_2344_ _0713_ vssd1 vssd1 vccd1 vccd1 _0802_ sky130_fd_sc_hd__clkbuf_4
XFILLER_0_20_481 vccd1 vssd1 vccd1 vssd1 sky130_ef_sc_hd__decap_12
XFILLER_0_58_76 vssd1 vssd1 vccd1 vccd1 sky130_fd_sc_hd__decap_8
X_2275_ _0732_ vssd1 vssd1 vccd1 vccd1 _0733_ sky130_fd_sc_hd__buf_4
XFILLER_0_74_53 vccd1 vssd1 vccd1 vssd1 sky130_ef_sc_hd__decap_12
X_4014_ net209 vssd1 vssd1 vccd1 vccd1 _2003_ sky130_fd_sc_hd__clkbuf_1
XFILLER_0_74_97 vssd1 vssd1 vccd1 vccd1 sky130_fd_sc_hd__fill_2
XFILLER_0_47_334 vssd1 vssd1 vccd1 vccd1 sky130_fd_sc_hd__fill_2
XFILLER_0_7_442 vssd1 vssd1 vccd1 vccd1 sky130_fd_sc_hd__decap_3
XFILLER_0_47_378 vssd1 vssd1 vccd1 vccd1 sky130_fd_sc_hd__decap_8
XFILLER_0_62_326 vssd1 vssd1 vccd1 vccd1 sky130_fd_sc_hd__fill_1
X_4778_ clknet_leaf_25_clk _0546_ vssd1 vssd1 vccd1 vccd1 u_core.u_regfile.rf\[3\]\[11\]
+ sky130_fd_sc_hd__dfxtp_1
XFILLER_0_15_264 vccd1 vssd1 vccd1 vssd1 sky130_ef_sc_hd__decap_12
X_3729_ net343 vssd1 vssd1 vccd1 vccd1 _1857_ sky130_fd_sc_hd__clkbuf_1
XFILLER_0_85_429 vssd1 vssd1 vccd1 vccd1 sky130_fd_sc_hd__fill_1
XFILLER_0_38_389 vssd1 vssd1 vccd1 vccd1 sky130_fd_sc_hd__decap_8
XFILLER_0_65_142 vssd1 vssd1 vccd1 vccd1 sky130_fd_sc_hd__fill_2
XFILLER_0_80_123 vssd1 vssd1 vccd1 vccd1 sky130_fd_sc_hd__fill_1
XTAP_407 vssd1 vccd1 sky130_fd_sc_hd__tapvpwrvgnd_1
XTAP_418 vssd1 vccd1 sky130_fd_sc_hd__tapvpwrvgnd_1
XTAP_429 vssd1 vccd1 sky130_fd_sc_hd__tapvpwrvgnd_1
XFILLER_0_76_429 vssd1 vssd1 vccd1 vccd1 sky130_fd_sc_hd__decap_3
XFILLER_0_76_418 vssd1 vssd1 vccd1 vccd1 sky130_fd_sc_hd__fill_2
XFILLER_0_29_334 vssd1 vssd1 vccd1 vccd1 sky130_fd_sc_hd__fill_2
X_2962_ _1073_ _1102_ _1138_ vssd1 vssd1 vccd1 vccd1 _1420_ sky130_fd_sc_hd__a21oi_2
XFILLER_0_29_356 vssd1 vssd1 vccd1 vccd1 sky130_fd_sc_hd__decap_3
X_4701_ clknet_leaf_33_clk _0502_ vssd1 vssd1 vccd1 vccd1 u_core.u_regfile.rf\[25\]\[7\]
+ sky130_fd_sc_hd__dfxtp_1
X_2893_ _0781_ _1350_ _1203_ vssd1 vssd1 vccd1 vccd1 _1351_ sky130_fd_sc_hd__o21ai_2
XFILLER_0_56_197 vssd1 vssd1 vccd1 vccd1 sky130_fd_sc_hd__decap_4
X_4632_ clknet_leaf_24_clk _0433_ vssd1 vssd1 vccd1 vccd1 u_core.u_regfile.rf\[26\]\[2\]
+ sky130_fd_sc_hd__dfxtp_1
XFILLER_0_71_145 vssd1 vssd1 vccd1 vccd1 sky130_fd_sc_hd__fill_1
XFILLER_0_4_412 vssd1 vssd1 vccd1 vccd1 sky130_fd_sc_hd__decap_3
XFILLER_0_44_359 vssd1 vssd1 vccd1 vccd1 sky130_fd_sc_hd__decap_4
XFILLER_0_71_189 vssd1 vssd1 vccd1 vccd1 sky130_fd_sc_hd__fill_2
XFILLER_0_4_445 vccd1 vssd1 vccd1 vssd1 sky130_ef_sc_hd__decap_12
X_4563_ clknet_leaf_17_clk _0364_ vssd1 vssd1 vccd1 vccd1 u_core.u_regfile.rf\[28\]\[29\]
+ sky130_fd_sc_hd__dfxtp_1
X_4494_ clknet_leaf_37_clk _0295_ vssd1 vssd1 vccd1 vccd1 u_core.u_regfile.rf\[30\]\[24\]
+ sky130_fd_sc_hd__dfxtp_1
XFILLER_0_4_489 vccd1 vssd1 vccd1 vssd1 sky130_ef_sc_hd__decap_12
X_3514_ net443 vssd1 vssd1 vccd1 vccd1 _1762_ sky130_fd_sc_hd__clkbuf_1
XFILLER_0_69_64 vssd1 vssd1 vccd1 vccd1 sky130_fd_sc_hd__decap_8
X_3445_ _1705_ _1706_ _1714_ _1715_ _0620_ vssd1 vssd1 vccd1 vccd1 _1719_ sky130_fd_sc_hd__a41o_1
XTAP_952 vssd1 vccd1 sky130_fd_sc_hd__tapvpwrvgnd_1
XTAP_941 vssd1 vccd1 sky130_fd_sc_hd__tapvpwrvgnd_1
XTAP_930 vssd1 vccd1 sky130_fd_sc_hd__tapvpwrvgnd_1
X_3376_ _1484_ vssd1 vssd1 vccd1 vccd1 _1672_ sky130_fd_sc_hd__clkbuf_4
XTAP_963 vssd1 vccd1 sky130_fd_sc_hd__tapvpwrvgnd_1
XFILLER_0_85_85 vccd1 vssd1 vccd1 vssd1 sky130_ef_sc_hd__decap_12
X_2327_ _0716_ u_core.u_regfile.rf\[7\]\[28\] _0754_ _0756_ _0784_ vssd1 vssd1 vccd1
+ vccd1 _0785_ sky130_fd_sc_hd__a311o_1
XFILLER_0_33_3 vssd1 vssd1 vccd1 vccd1 sky130_fd_sc_hd__decap_8
X_2258_ _0715_ vssd1 vssd1 vccd1 vccd1 _0716_ sky130_fd_sc_hd__clkbuf_8
XFILLER_0_79_201 vssd1 vssd1 vccd1 vccd1 sky130_fd_sc_hd__decap_3
X_2189_ _0638_ u_timer.count_reg\[4\] _0646_ _0647_ vssd1 vssd1 vccd1 vccd1 _0648_
+ sky130_fd_sc_hd__a22o_1
XFILLER_0_47_164 vssd1 vssd1 vccd1 vccd1 sky130_fd_sc_hd__decap_4
XFILLER_0_75_495 vssd1 vssd1 vccd1 vccd1 sky130_fd_sc_hd__decap_8
XFILLER_0_50_318 vssd1 vssd1 vccd1 vccd1 sky130_fd_sc_hd__fill_2
XFILLER_0_14_15 vssd1 vssd1 vccd1 vccd1 sky130_fd_sc_hd__decap_6
XTAP_204 vssd1 vccd1 sky130_fd_sc_hd__tapvpwrvgnd_1
XTAP_215 vssd1 vccd1 sky130_fd_sc_hd__tapvpwrvgnd_1
XFILLER_0_39_45 vssd1 vssd1 vccd1 vccd1 sky130_fd_sc_hd__fill_2
XTAP_248 vssd1 vccd1 sky130_fd_sc_hd__tapvpwrvgnd_1
XTAP_237 vssd1 vccd1 sky130_fd_sc_hd__tapvpwrvgnd_1
XTAP_226 vssd1 vccd1 sky130_fd_sc_hd__tapvpwrvgnd_1
X_3230_ _1616_ vssd1 vssd1 vccd1 vccd1 _0072_ sky130_fd_sc_hd__clkbuf_1
XFILLER_0_39_67 vccd1 vssd1 vccd1 vssd1 sky130_ef_sc_hd__decap_12
XTAP_259 vssd1 vccd1 sky130_fd_sc_hd__tapvpwrvgnd_1
X_3161_ u_audio.counter\[7\] _1562_ u_audio.counter\[6\] _1577_ vssd1 vssd1 vccd1
+ vccd1 _1582_ sky130_fd_sc_hd__o211a_1
X_3092_ u_timer.count_reg\[15\] u_timer.count_reg\[14\] _1522_ u_timer.count_reg\[16\]
+ vssd1 vssd1 vccd1 vccd1 _1529_ sky130_fd_sc_hd__a31o_1
XFILLER_0_49_418 vssd1 vssd1 vccd1 vccd1 sky130_fd_sc_hd__decap_8
X_3994_ net180 vssd1 vssd1 vccd1 vccd1 _1993_ sky130_fd_sc_hd__clkbuf_1
XFILLER_0_72_421 vssd1 vssd1 vccd1 vccd1 sky130_fd_sc_hd__decap_8
XFILLER_0_17_315 vssd1 vssd1 vccd1 vccd1 sky130_fd_sc_hd__fill_2
X_2945_ _0775_ _0767_ vssd1 vssd1 vccd1 vccd1 _1403_ sky130_fd_sc_hd__nor2_1
XFILLER_0_44_156 vssd1 vssd1 vccd1 vccd1 sky130_fd_sc_hd__decap_8
X_2876_ _0833_ _1297_ vssd1 vssd1 vccd1 vccd1 _1334_ sky130_fd_sc_hd__or2_1
X_4615_ clknet_leaf_47_clk _0416_ vssd1 vssd1 vccd1 vccd1 u_core.u_regfile.rf\[1\]\[17\]
+ sky130_fd_sc_hd__dfxtp_1
XFILLER_0_32_307 vssd1 vssd1 vccd1 vccd1 sky130_fd_sc_hd__fill_1
Xhold400 u_core.u_regfile.rf\[1\]\[10\] vssd1 vssd1 vccd1 vccd1 net433 sky130_fd_sc_hd__dlygate4sd3_1
XFILLER_0_4_253 vssd1 vssd1 vccd1 vccd1 sky130_fd_sc_hd__fill_2
X_4546_ clknet_leaf_43_clk _0347_ vssd1 vssd1 vccd1 vccd1 u_core.u_regfile.rf\[28\]\[12\]
+ sky130_fd_sc_hd__dfxtp_1
Xhold411 u_core.u_regfile.rf\[29\]\[5\] vssd1 vssd1 vccd1 vccd1 net444 sky130_fd_sc_hd__dlygate4sd3_1
Xhold433 u_timer.count_reg\[31\] vssd1 vssd1 vccd1 vccd1 net466 sky130_fd_sc_hd__dlygate4sd3_1
Xhold444 u_core.u_regfile.rf\[1\]\[21\] vssd1 vssd1 vccd1 vccd1 net477 sky130_fd_sc_hd__dlygate4sd3_1
Xhold422 u_core.u_regfile.rf\[1\]\[17\] vssd1 vssd1 vccd1 vccd1 net455 sky130_fd_sc_hd__dlygate4sd3_1
Xhold455 u_core.u_regfile.rf\[4\]\[26\] vssd1 vssd1 vccd1 vccd1 net488 sky130_fd_sc_hd__dlygate4sd3_1
X_4477_ clknet_leaf_26_clk _0278_ vssd1 vssd1 vccd1 vccd1 u_core.u_regfile.rf\[30\]\[7\]
+ sky130_fd_sc_hd__dfxtp_1
Xhold477 u_core.u_regfile.rf\[31\]\[0\] vssd1 vssd1 vccd1 vccd1 net510 sky130_fd_sc_hd__dlygate4sd3_1
Xhold466 u_audio.sample_reg\[4\] vssd1 vssd1 vccd1 vccd1 net499 sky130_fd_sc_hd__dlygate4sd3_1
Xhold499 u_timer.count_reg\[22\] vssd1 vssd1 vccd1 vccd1 net532 sky130_fd_sc_hd__dlygate4sd3_1
Xhold488 net8 vssd1 vssd1 vccd1 vccd1 net521 sky130_fd_sc_hd__dlygate4sd3_1
X_3428_ _1679_ vssd1 vssd1 vccd1 vccd1 _1704_ sky130_fd_sc_hd__clkbuf_4
X_3359_ _1482_ _1666_ _1667_ net43 vssd1 vssd1 vccd1 vccd1 _0150_ sky130_fd_sc_hd__o31a_1
XTAP_760 vssd1 vccd1 sky130_fd_sc_hd__tapvpwrvgnd_1
XTAP_771 vssd1 vccd1 sky130_fd_sc_hd__tapvpwrvgnd_1
XTAP_782 vssd1 vccd1 sky130_fd_sc_hd__tapvpwrvgnd_1
XTAP_793 vssd1 vccd1 sky130_fd_sc_hd__tapvpwrvgnd_1
XFILLER_0_35_178 vssd1 vssd1 vccd1 vccd1 sky130_fd_sc_hd__decap_3
XFILLER_0_63_476 vssd1 vssd1 vccd1 vccd1 sky130_fd_sc_hd__fill_2
XFILLER_0_50_126 vssd1 vssd1 vccd1 vccd1 sky130_fd_sc_hd__decap_8
XFILLER_0_25_47 vssd1 vssd1 vccd1 vccd1 sky130_fd_sc_hd__decap_4
XFILLER_0_58_248 vssd1 vssd1 vccd1 vccd1 sky130_fd_sc_hd__decap_4
XFILLER_0_41_57 vssd1 vssd1 vccd1 vccd1 sky130_fd_sc_hd__fill_2
X_2730_ _0770_ _1186_ _0702_ _0881_ _1187_ vssd1 vssd1 vccd1 vccd1 _1188_ sky130_fd_sc_hd__a221o_1
XFILLER_0_41_68 vssd1 vssd1 vccd1 vccd1 sky130_fd_sc_hd__fill_1
XFILLER_0_14_318 vssd1 vssd1 vccd1 vccd1 sky130_fd_sc_hd__fill_1
X_2661_ _0900_ _1117_ _1118_ _0723_ vssd1 vssd1 vccd1 vccd1 _1119_ sky130_fd_sc_hd__o211a_1
X_4400_ clknet_leaf_8_clk _0211_ vssd1 vssd1 vccd1 vccd1 u_core.u_regfile.rf\[29\]\[4\]
+ sky130_fd_sc_hd__dfxtp_1
X_2592_ _1034_ _1048_ _1049_ vssd1 vssd1 vccd1 vccd1 _1050_ sky130_fd_sc_hd__o21ai_2
X_4331_ clknet_leaf_3_clk _0142_ vssd1 vssd1 vccd1 vccd1 u_core.u_regfile.rf\[4\]\[31\]
+ sky130_fd_sc_hd__dfxtp_1
X_4262_ clknet_leaf_9_clk _0077_ vssd1 vssd1 vccd1 vccd1 u_core.u_regfile.rf\[31\]\[30\]
+ sky130_fd_sc_hd__dfxtp_1
XFILLER_0_5_68 vssd1 vssd1 vccd1 vccd1 sky130_fd_sc_hd__fill_2
X_3213_ net536 vssd1 vssd1 vccd1 vccd1 _1608_ sky130_fd_sc_hd__clkbuf_1
X_4193_ _2096_ vssd1 vssd1 vccd1 vccd1 _0555_ sky130_fd_sc_hd__clkbuf_1
X_3144_ net471 vssd1 vssd1 vccd1 vccd1 _1565_ sky130_fd_sc_hd__inv_2
X_3075_ _1515_ _1495_ _1516_ vssd1 vssd1 vccd1 vccd1 _1517_ sky130_fd_sc_hd__and3b_1
XFILLER_0_82_53 vccd1 vssd1 vccd1 vssd1 sky130_ef_sc_hd__decap_12
X_3977_ _1984_ vssd1 vssd1 vccd1 vccd1 _0451_ sky130_fd_sc_hd__clkbuf_1
XFILLER_0_17_145 vssd1 vssd1 vccd1 vccd1 sky130_fd_sc_hd__decap_6
X_2928_ _1384_ _1385_ vssd1 vssd1 vccd1 vccd1 _1386_ sky130_fd_sc_hd__nor2_1
XFILLER_0_72_273 vccd1 vssd1 vccd1 vssd1 sky130_ef_sc_hd__decap_12
X_2859_ u_core.u_regfile.rf\[29\]\[31\] u_core.u_regfile.rf\[31\]\[31\] _0706_ vssd1
+ vssd1 vccd1 vccd1 _1317_ sky130_fd_sc_hd__mux2_1
Xhold230 u_core.u_regfile.rf\[25\]\[1\] vssd1 vssd1 vccd1 vccd1 net263 sky130_fd_sc_hd__dlygate4sd3_1
X_4529_ clknet_leaf_35_clk _0330_ vssd1 vssd1 vccd1 vccd1 u_core.u_regfile.rf\[2\]\[27\]
+ sky130_fd_sc_hd__dfxtp_1
Xhold241 u_core.u_regfile.rf\[3\]\[2\] vssd1 vssd1 vccd1 vccd1 net274 sky130_fd_sc_hd__dlygate4sd3_1
Xhold252 u_core.u_regfile.rf\[30\]\[23\] vssd1 vssd1 vccd1 vccd1 net285 sky130_fd_sc_hd__dlygate4sd3_1
Xhold285 u_core.u_regfile.rf\[3\]\[1\] vssd1 vssd1 vccd1 vccd1 net318 sky130_fd_sc_hd__dlygate4sd3_1
Xhold296 u_core.u_regfile.rf\[30\]\[1\] vssd1 vssd1 vccd1 vccd1 net329 sky130_fd_sc_hd__dlygate4sd3_1
Xhold263 u_core.u_regfile.rf\[24\]\[27\] vssd1 vssd1 vccd1 vccd1 net296 sky130_fd_sc_hd__dlygate4sd3_1
Xhold274 u_core.u_regfile.rf\[3\]\[4\] vssd1 vssd1 vccd1 vccd1 net307 sky130_fd_sc_hd__dlygate4sd3_1
XTAP_590 vssd1 vccd1 sky130_fd_sc_hd__tapvpwrvgnd_1
XFILLER_0_83_505 vssd1 vssd1 vccd1 vccd1 sky130_fd_sc_hd__decap_4
XFILLER_0_48_270 vssd1 vssd1 vccd1 vccd1 sky130_fd_sc_hd__fill_2
XFILLER_0_11_27 vssd1 vssd1 vccd1 vccd1 sky130_fd_sc_hd__decap_8
XFILLER_0_63_262 vccd1 vssd1 vccd1 vssd1 sky130_ef_sc_hd__decap_12
XFILLER_0_51_446 vssd1 vssd1 vccd1 vccd1 sky130_fd_sc_hd__fill_2
XFILLER_0_23_159 vssd1 vssd1 vccd1 vccd1 sky130_fd_sc_hd__fill_2
XFILLER_0_74_505 vssd1 vssd1 vccd1 vccd1 sky130_fd_sc_hd__fill_1
X_3900_ net432 vssd1 vssd1 vccd1 vccd1 _1946_ sky130_fd_sc_hd__clkbuf_1
X_3831_ _1911_ vssd1 vssd1 vccd1 vccd1 _0378_ sky130_fd_sc_hd__clkbuf_1
XFILLER_0_39_281 vssd1 vssd1 vccd1 vccd1 sky130_fd_sc_hd__decap_4
X_3762_ _0712_ vssd1 vssd1 vccd1 vccd1 _1876_ sky130_fd_sc_hd__clkbuf_4
XFILLER_0_54_240 vccd1 vssd1 vccd1 vssd1 sky130_ef_sc_hd__decap_12
XFILLER_0_14_104 vssd1 vssd1 vccd1 vccd1 sky130_fd_sc_hd__decap_3
XFILLER_0_6_337 vssd1 vssd1 vccd1 vccd1 sky130_fd_sc_hd__decap_4
X_2713_ _1168_ _1169_ _0885_ _1170_ vssd1 vssd1 vccd1 vccd1 _1171_ sky130_fd_sc_hd__a31oi_4
X_3693_ net225 vssd1 vssd1 vccd1 vccd1 _1839_ sky130_fd_sc_hd__clkbuf_1
X_2644_ _1086_ _1087_ _1100_ _1101_ vssd1 vssd1 vccd1 vccd1 _1102_ sky130_fd_sc_hd__and4_2
X_2575_ _0770_ _0722_ _0692_ u_core.u_regfile.rf\[5\]\[0\] _1032_ vssd1 vssd1 vccd1
+ vccd1 _1033_ sky130_fd_sc_hd__o221a_1
X_4314_ clknet_leaf_46_clk _0125_ vssd1 vssd1 vccd1 vccd1 u_core.u_regfile.rf\[4\]\[14\]
+ sky130_fd_sc_hd__dfxtp_1
XFILLER_0_10_365 vssd1 vssd1 vccd1 vccd1 sky130_fd_sc_hd__fill_2
X_4245_ clknet_leaf_32_clk _0060_ vssd1 vssd1 vccd1 vccd1 u_core.u_regfile.rf\[31\]\[13\]
+ sky130_fd_sc_hd__dfxtp_1
X_4176_ net360 vssd1 vssd1 vccd1 vccd1 _2088_ sky130_fd_sc_hd__clkbuf_1
X_3127_ u_timer.count_reg\[26\] u_timer.count_reg\[25\] u_timer.count_reg\[24\] _1544_
+ u_timer.count_reg\[27\] vssd1 vssd1 vccd1 vccd1 _1553_ sky130_fd_sc_hd__a41o_1
X_3058_ _1504_ vssd1 vssd1 vccd1 vccd1 _0035_ sky130_fd_sc_hd__clkbuf_1
XFILLER_0_77_310 vssd1 vssd1 vccd1 vccd1 sky130_fd_sc_hd__fill_2
XFILLER_0_65_505 vssd1 vssd1 vccd1 vccd1 sky130_fd_sc_hd__decap_4
XFILLER_0_77_387 vssd1 vssd1 vccd1 vccd1 sky130_fd_sc_hd__decap_4
XFILLER_0_18_421 vssd1 vssd1 vccd1 vccd1 sky130_fd_sc_hd__fill_2
XFILLER_0_33_424 vssd1 vssd1 vccd1 vccd1 sky130_fd_sc_hd__decap_4
XFILLER_0_33_446 vssd1 vssd1 vccd1 vccd1 sky130_fd_sc_hd__fill_2
XFILLER_0_33_457 vssd1 vssd1 vccd1 vccd1 sky130_fd_sc_hd__fill_2
XFILLER_0_60_298 vssd1 vssd1 vccd1 vccd1 sky130_fd_sc_hd__fill_1
XFILLER_0_68_321 vssd1 vssd1 vccd1 vccd1 sky130_fd_sc_hd__fill_1
XFILLER_0_68_365 vssd1 vssd1 vccd1 vccd1 sky130_fd_sc_hd__decap_4
XFILLER_0_22_15 vccd1 vssd1 vccd1 vssd1 sky130_ef_sc_hd__decap_12
XPHY_60 vssd1 vssd1 vccd1 vccd1 sky130_fd_sc_hd__decap_3
XPHY_71 vssd1 vssd1 vccd1 vccd1 sky130_fd_sc_hd__decap_3
XPHY_82 vssd1 vssd1 vccd1 vccd1 sky130_fd_sc_hd__decap_3
XPHY_93 vssd1 vssd1 vccd1 vccd1 sky130_fd_sc_hd__decap_3
XFILLER_0_36_251 vssd1 vssd1 vccd1 vccd1 sky130_fd_sc_hd__fill_1
XFILLER_0_3_329 vssd1 vssd1 vccd1 vccd1 sky130_fd_sc_hd__decap_6
XFILLER_0_51_265 vssd1 vssd1 vccd1 vccd1 sky130_fd_sc_hd__decap_4
X_2360_ _0817_ _0711_ _0716_ vssd1 vssd1 vccd1 vccd1 _0818_ sky130_fd_sc_hd__and3_1
X_2291_ _0687_ _0695_ _0688_ vssd1 vssd1 vccd1 vccd1 _0749_ sky130_fd_sc_hd__a21boi_4
X_4030_ net267 vssd1 vssd1 vccd1 vccd1 _2011_ sky130_fd_sc_hd__clkbuf_1
XFILLER_0_63_55 vssd1 vssd1 vccd1 vccd1 sky130_fd_sc_hd__fill_1
Xclkbuf_leaf_44_clk clknet_2_0__leaf_clk vssd1 vssd1 vccd1 vccd1 clknet_leaf_44_clk
+ sky130_fd_sc_hd__clkbuf_16
XFILLER_0_47_505 vssd1 vssd1 vccd1 vccd1 sky130_fd_sc_hd__decap_4
XFILLER_0_19_229 vssd1 vssd1 vccd1 vccd1 sky130_fd_sc_hd__fill_1
XFILLER_0_74_368 vccd1 vssd1 vccd1 vssd1 sky130_ef_sc_hd__decap_12
X_3814_ net257 vssd1 vssd1 vccd1 vccd1 _1903_ sky130_fd_sc_hd__clkbuf_1
X_4794_ clknet_leaf_26_clk _0562_ vssd1 vssd1 vccd1 vccd1 u_core.u_regfile.rf\[3\]\[27\]
+ sky130_fd_sc_hd__dfxtp_1
X_3745_ _1674_ _1862_ net70 vssd1 vssd1 vccd1 vccd1 _1866_ sky130_fd_sc_hd__o21ai_1
X_3676_ _1830_ vssd1 vssd1 vccd1 vccd1 _0304_ sky130_fd_sc_hd__clkbuf_1
X_2627_ _1083_ _1084_ vssd1 vssd1 vccd1 vccd1 _1085_ sky130_fd_sc_hd__nand2_4
XFILLER_0_63_3 vssd1 vssd1 vccd1 vccd1 sky130_fd_sc_hd__decap_8
XFILLER_0_10_151 vccd1 vssd1 vccd1 vssd1 sky130_ef_sc_hd__decap_12
X_2558_ _0776_ u_core.u_regfile.rf\[29\]\[3\] _1015_ vssd1 vssd1 vccd1 vccd1 _1016_
+ sky130_fd_sc_hd__a21oi_1
X_2489_ _0730_ _0686_ u_core.u_regfile.rf\[28\]\[9\] vssd1 vssd1 vccd1 vccd1 _0947_
+ sky130_fd_sc_hd__o21a_1
X_4228_ _1700_ _1112_ net13 _1332_ net11 vssd1 vssd1 vccd1 vccd1 _2114_ sky130_fd_sc_hd__o2111a_1
X_4159_ _2079_ vssd1 vssd1 vccd1 vccd1 _0538_ sky130_fd_sc_hd__clkbuf_1
Xmax_cap16 _1295_ vssd1 vssd1 vccd1 vccd1 net16 sky130_fd_sc_hd__buf_1
Xclkbuf_leaf_35_clk clknet_2_1__leaf_clk vssd1 vssd1 vccd1 vccd1 clknet_leaf_35_clk
+ sky130_fd_sc_hd__clkbuf_16
XFILLER_0_80_305 vssd1 vssd1 vccd1 vccd1 sky130_fd_sc_hd__decap_3
XFILLER_0_53_508 vssd1 vssd1 vccd1 vccd1 sky130_fd_sc_hd__fill_2
XFILLER_0_73_390 vssd1 vssd1 vccd1 vccd1 sky130_fd_sc_hd__fill_2
XFILLER_0_21_427 vssd1 vssd1 vccd1 vccd1 sky130_fd_sc_hd__fill_1
XFILLER_0_17_15 vccd1 vssd1 vccd1 vssd1 sky130_ef_sc_hd__decap_12
XFILLER_0_29_505 vssd1 vssd1 vccd1 vccd1 sky130_fd_sc_hd__decap_4
Xclkbuf_leaf_26_clk clknet_2_3__leaf_clk vssd1 vssd1 vccd1 vccd1 clknet_leaf_26_clk
+ sky130_fd_sc_hd__clkbuf_16
X_3530_ net387 vssd1 vssd1 vccd1 vccd1 _1770_ sky130_fd_sc_hd__clkbuf_1
X_3461_ _0933_ _1704_ _1729_ vssd1 vssd1 vccd1 vccd1 _0190_ sky130_fd_sc_hd__o21ai_1
X_2412_ _0859_ _0869_ vssd1 vssd1 vccd1 vccd1 _0870_ sky130_fd_sc_hd__nor2_1
X_3392_ _1452_ _1457_ _1451_ _1448_ vssd1 vssd1 vccd1 vccd1 _1676_ sky130_fd_sc_hd__nand4_2
X_2343_ u_core.u_regfile.rf\[29\]\[27\] u_core.u_regfile.rf\[31\]\[27\] _0705_ vssd1
+ vssd1 vccd1 vccd1 _0801_ sky130_fd_sc_hd__mux2_1
X_2274_ _0685_ _0686_ vssd1 vssd1 vccd1 vccd1 _0732_ sky130_fd_sc_hd__nor2_2
X_4013_ _2002_ vssd1 vssd1 vccd1 vccd1 _0469_ sky130_fd_sc_hd__clkbuf_1
XFILLER_0_79_405 vccd1 vssd1 vccd1 vssd1 sky130_ef_sc_hd__decap_12
XFILLER_0_74_65 vccd1 vssd1 vccd1 vssd1 sky130_ef_sc_hd__decap_12
XFILLER_0_79_449 vccd1 vssd1 vccd1 vssd1 sky130_ef_sc_hd__decap_12
XFILLER_0_59_140 vssd1 vssd1 vccd1 vccd1 sky130_fd_sc_hd__decap_6
XFILLER_0_59_162 vssd1 vssd1 vccd1 vccd1 sky130_fd_sc_hd__decap_6
Xclkbuf_leaf_17_clk clknet_2_2__leaf_clk vssd1 vssd1 vccd1 vccd1 clknet_leaf_17_clk
+ sky130_fd_sc_hd__clkbuf_16
XFILLER_0_47_357 vssd1 vssd1 vccd1 vccd1 sky130_fd_sc_hd__decap_3
XFILLER_0_74_187 vssd1 vssd1 vccd1 vccd1 sky130_fd_sc_hd__fill_1
XFILLER_0_7_465 vssd1 vssd1 vccd1 vccd1 sky130_fd_sc_hd__fill_1
X_4777_ clknet_leaf_49_clk _0545_ vssd1 vssd1 vccd1 vccd1 u_core.u_regfile.rf\[3\]\[10\]
+ sky130_fd_sc_hd__dfxtp_1
XFILLER_0_15_276 vssd1 vssd1 vccd1 vccd1 sky130_fd_sc_hd__decap_4
X_3728_ _1856_ vssd1 vssd1 vccd1 vccd1 _0330_ sky130_fd_sc_hd__clkbuf_1
X_3659_ net226 vssd1 vssd1 vccd1 vccd1 _1822_ sky130_fd_sc_hd__clkbuf_1
XFILLER_0_61_393 vssd1 vssd1 vccd1 vccd1 sky130_fd_sc_hd__decap_3
XTAP_408 vssd1 vccd1 sky130_fd_sc_hd__tapvpwrvgnd_1
XTAP_419 vssd1 vccd1 sky130_fd_sc_hd__tapvpwrvgnd_1
X_2961_ _1418_ vssd1 vssd1 vccd1 vccd1 _1419_ sky130_fd_sc_hd__inv_2
X_4700_ clknet_leaf_25_clk _0501_ vssd1 vssd1 vccd1 vccd1 u_core.u_regfile.rf\[25\]\[6\]
+ sky130_fd_sc_hd__dfxtp_1
X_4631_ clknet_leaf_37_clk _0432_ vssd1 vssd1 vccd1 vccd1 u_core.u_regfile.rf\[26\]\[1\]
+ sky130_fd_sc_hd__dfxtp_1
X_2892_ _1198_ _1204_ vssd1 vssd1 vccd1 vccd1 _1350_ sky130_fd_sc_hd__nand2_2
XFILLER_0_60_78 vssd1 vssd1 vccd1 vccd1 sky130_fd_sc_hd__decap_6
XFILLER_0_4_457 vccd1 vssd1 vccd1 vssd1 sky130_ef_sc_hd__decap_12
X_4562_ clknet_leaf_18_clk _0363_ vssd1 vssd1 vccd1 vccd1 u_core.u_regfile.rf\[28\]\[28\]
+ sky130_fd_sc_hd__dfxtp_1
XFILLER_0_8_79 vssd1 vssd1 vccd1 vccd1 sky130_fd_sc_hd__decap_4
X_4493_ clknet_leaf_32_clk _0294_ vssd1 vssd1 vccd1 vccd1 u_core.u_regfile.rf\[30\]\[23\]
+ sky130_fd_sc_hd__dfxtp_1
X_3513_ _1761_ vssd1 vssd1 vccd1 vccd1 _0210_ sky130_fd_sc_hd__clkbuf_1
XFILLER_0_12_268 vssd1 vssd1 vccd1 vccd1 sky130_fd_sc_hd__fill_1
Xclkbuf_leaf_6_clk clknet_2_2__leaf_clk vssd1 vssd1 vccd1 vccd1 clknet_leaf_6_clk
+ sky130_fd_sc_hd__clkbuf_16
X_3444_ _1717_ _1704_ _1718_ vssd1 vssd1 vccd1 vccd1 _0184_ sky130_fd_sc_hd__o21ai_1
XFILLER_0_69_98 vccd1 vssd1 vccd1 vssd1 sky130_ef_sc_hd__decap_12
XTAP_953 vssd1 vccd1 sky130_fd_sc_hd__tapvpwrvgnd_1
XTAP_942 vssd1 vccd1 sky130_fd_sc_hd__tapvpwrvgnd_1
XTAP_931 vssd1 vccd1 sky130_fd_sc_hd__tapvpwrvgnd_1
XTAP_920 vssd1 vccd1 sky130_fd_sc_hd__tapvpwrvgnd_1
X_3375_ _1671_ _1669_ _1670_ net377 vssd1 vssd1 vccd1 vccd1 _0162_ sky130_fd_sc_hd__o31a_1
X_2326_ _0759_ _0762_ u_core.u_regfile.rf\[6\]\[28\] vssd1 vssd1 vccd1 vccd1 _0784_
+ sky130_fd_sc_hd__o21a_1
XFILLER_0_85_97 vccd1 vssd1 vccd1 vssd1 sky130_ef_sc_hd__decap_12
X_2257_ _0714_ vssd1 vssd1 vccd1 vccd1 _0715_ sky130_fd_sc_hd__buf_4
XFILLER_0_26_3 vssd1 vssd1 vccd1 vccd1 sky130_fd_sc_hd__decap_8
XFILLER_0_79_257 vssd1 vssd1 vccd1 vccd1 sky130_fd_sc_hd__fill_1
X_2188_ u_timer.count_reg\[3\] _0639_ vssd1 vssd1 vccd1 vccd1 _0647_ sky130_fd_sc_hd__or2_1
XFILLER_0_35_305 vssd1 vssd1 vccd1 vccd1 sky130_fd_sc_hd__fill_1
XFILLER_0_62_157 vccd1 vssd1 vccd1 vssd1 sky130_ef_sc_hd__decap_12
XFILLER_0_43_371 vssd1 vssd1 vccd1 vccd1 sky130_fd_sc_hd__fill_1
XFILLER_0_43_393 vssd1 vssd1 vccd1 vccd1 sky130_fd_sc_hd__fill_1
XFILLER_0_11_290 vssd1 vssd1 vccd1 vccd1 sky130_fd_sc_hd__decap_3
XFILLER_0_38_121 vssd1 vssd1 vccd1 vccd1 sky130_fd_sc_hd__decap_6
XFILLER_0_26_349 vssd1 vssd1 vccd1 vccd1 sky130_fd_sc_hd__fill_2
XFILLER_0_1_405 vccd1 vssd1 vccd1 vssd1 sky130_ef_sc_hd__decap_12
XFILLER_0_34_393 vssd1 vssd1 vccd1 vccd1 sky130_fd_sc_hd__fill_2
XFILLER_0_1_449 vccd1 vssd1 vccd1 vssd1 sky130_ef_sc_hd__decap_12
XTAP_205 vssd1 vccd1 sky130_fd_sc_hd__tapvpwrvgnd_1
XTAP_238 vssd1 vccd1 sky130_fd_sc_hd__tapvpwrvgnd_1
XTAP_227 vssd1 vccd1 sky130_fd_sc_hd__tapvpwrvgnd_1
XTAP_216 vssd1 vccd1 sky130_fd_sc_hd__tapvpwrvgnd_1
XFILLER_0_39_79 vccd1 vssd1 vccd1 vssd1 sky130_ef_sc_hd__decap_12
XTAP_249 vssd1 vccd1 sky130_fd_sc_hd__tapvpwrvgnd_1
X_3160_ _1562_ u_audio.counter\[7\] _1578_ _1579_ _1580_ vssd1 vssd1 vccd1 vccd1 _1581_
+ sky130_fd_sc_hd__o2111a_1
X_3091_ u_timer.count_reg\[15\] _1525_ _1528_ _1490_ vssd1 vssd1 vccd1 vccd1 _0013_
+ sky130_fd_sc_hd__o211a_1
Xhold1 u_audio.counter\[0\] vssd1 vssd1 vccd1 vccd1 net34 sky130_fd_sc_hd__dlymetal6s2s_1
XFILLER_0_9_505 vssd1 vssd1 vccd1 vccd1 sky130_fd_sc_hd__decap_4
XFILLER_0_29_110 vssd1 vssd1 vccd1 vccd1 sky130_fd_sc_hd__fill_2
XFILLER_0_29_132 vssd1 vssd1 vccd1 vccd1 sky130_fd_sc_hd__decap_3
X_3993_ _1992_ vssd1 vssd1 vccd1 vccd1 _0459_ sky130_fd_sc_hd__clkbuf_1
X_2944_ _1388_ _1389_ _1392_ _1398_ _1401_ vssd1 vssd1 vccd1 vccd1 _1402_ sky130_fd_sc_hd__o2111a_1
XFILLER_0_44_135 vssd1 vssd1 vccd1 vccd1 sky130_fd_sc_hd__decap_4
X_2875_ _0821_ vssd1 vssd1 vccd1 vccd1 _1333_ sky130_fd_sc_hd__inv_2
XFILLER_0_72_488 vccd1 vssd1 vccd1 vssd1 sky130_ef_sc_hd__decap_12
XFILLER_0_4_221 vssd1 vssd1 vccd1 vccd1 sky130_fd_sc_hd__fill_1
X_4614_ clknet_leaf_32_clk _0415_ vssd1 vssd1 vccd1 vccd1 u_core.u_regfile.rf\[1\]\[16\]
+ sky130_fd_sc_hd__dfxtp_1
XFILLER_0_44_168 vssd1 vssd1 vccd1 vccd1 sky130_fd_sc_hd__decap_4
XFILLER_0_25_393 vssd1 vssd1 vccd1 vccd1 sky130_fd_sc_hd__decap_8
X_4545_ clknet_leaf_30_clk _0346_ vssd1 vssd1 vccd1 vccd1 u_core.u_regfile.rf\[28\]\[11\]
+ sky130_fd_sc_hd__dfxtp_1
Xhold401 u_core.u_regfile.rf\[29\]\[23\] vssd1 vssd1 vccd1 vccd1 net434 sky130_fd_sc_hd__dlygate4sd3_1
Xhold434 u_timer.threshold_reg\[4\] vssd1 vssd1 vccd1 vccd1 net467 sky130_fd_sc_hd__dlygate4sd3_1
Xhold423 u_core.u_regfile.rf\[4\]\[20\] vssd1 vssd1 vccd1 vccd1 net456 sky130_fd_sc_hd__dlygate4sd3_1
Xhold412 u_core.u_regfile.rf\[1\]\[13\] vssd1 vssd1 vccd1 vccd1 net445 sky130_fd_sc_hd__dlygate4sd3_1
Xhold445 u_audio.sample_reg\[5\] vssd1 vssd1 vccd1 vccd1 net478 sky130_fd_sc_hd__dlygate4sd3_1
Xhold456 u_timer.threshold_reg\[1\] vssd1 vssd1 vccd1 vccd1 net489 sky130_fd_sc_hd__dlygate4sd3_1
Xhold467 u_core.u_regfile.rf\[31\]\[18\] vssd1 vssd1 vccd1 vccd1 net500 sky130_fd_sc_hd__dlygate4sd3_1
X_4476_ clknet_leaf_33_clk _0277_ vssd1 vssd1 vccd1 vccd1 u_core.u_regfile.rf\[30\]\[6\]
+ sky130_fd_sc_hd__dfxtp_1
Xhold478 u_core.u_regfile.rf\[1\]\[19\] vssd1 vssd1 vccd1 vccd1 net511 sky130_fd_sc_hd__dlygate4sd3_1
X_3427_ _0963_ _0964_ vssd1 vssd1 vccd1 vccd1 _1703_ sky130_fd_sc_hd__nand2_1
Xhold489 u_core.u_regfile.rf\[28\]\[9\] vssd1 vssd1 vccd1 vccd1 net522 sky130_fd_sc_hd__dlygate4sd3_1
X_3358_ _1482_ _1666_ _1667_ net371 vssd1 vssd1 vccd1 vccd1 _0149_ sky130_fd_sc_hd__o31a_1
XTAP_750 vssd1 vccd1 sky130_fd_sc_hd__tapvpwrvgnd_1
XTAP_761 vssd1 vccd1 sky130_fd_sc_hd__tapvpwrvgnd_1
X_2309_ u_core.u_regfile.rf\[31\]\[29\] _0728_ _0736_ net19 _0766_ vssd1 vssd1 vccd1
+ vccd1 _0767_ sky130_fd_sc_hd__o2111a_1
XTAP_772 vssd1 vccd1 sky130_fd_sc_hd__tapvpwrvgnd_1
XTAP_783 vssd1 vccd1 sky130_fd_sc_hd__tapvpwrvgnd_1
XTAP_794 vssd1 vccd1 sky130_fd_sc_hd__tapvpwrvgnd_1
X_3289_ _1635_ vssd1 vssd1 vccd1 vccd1 _0112_ sky130_fd_sc_hd__clkbuf_1
XFILLER_0_48_474 vssd1 vssd1 vccd1 vccd1 sky130_fd_sc_hd__fill_2
XFILLER_0_48_496 vccd1 vssd1 vccd1 vssd1 sky130_ef_sc_hd__decap_12
XFILLER_0_63_422 vccd1 vssd1 vccd1 vssd1 sky130_ef_sc_hd__decap_12
XFILLER_0_23_308 vssd1 vssd1 vccd1 vccd1 sky130_fd_sc_hd__decap_3
XFILLER_0_23_319 vssd1 vssd1 vccd1 vccd1 sky130_fd_sc_hd__fill_1
XFILLER_0_35_157 vssd1 vssd1 vccd1 vccd1 sky130_fd_sc_hd__fill_1
XFILLER_0_50_138 vssd1 vssd1 vccd1 vccd1 sky130_fd_sc_hd__fill_2
XFILLER_0_26_113 vssd1 vssd1 vccd1 vccd1 sky130_fd_sc_hd__fill_2
XFILLER_0_81_241 vssd1 vssd1 vccd1 vccd1 sky130_fd_sc_hd__fill_1
X_2660_ _0705_ _0709_ _0898_ _0899_ u_core.u_regfile.rf\[5\]\[7\] vssd1 vssd1 vccd1
+ vccd1 _1118_ sky130_fd_sc_hd__a221o_1
XFILLER_0_54_477 vccd1 vssd1 vccd1 vssd1 sky130_ef_sc_hd__decap_12
XFILLER_0_41_138 vssd1 vssd1 vccd1 vccd1 sky130_fd_sc_hd__fill_2
X_2591_ _1041_ _1047_ _0771_ _0706_ vssd1 vssd1 vccd1 vccd1 _1049_ sky130_fd_sc_hd__nand4_2
X_4330_ clknet_leaf_3_clk _0141_ vssd1 vssd1 vccd1 vccd1 u_core.u_regfile.rf\[4\]\[30\]
+ sky130_fd_sc_hd__dfxtp_1
XFILLER_0_1_279 vssd1 vssd1 vccd1 vccd1 sky130_fd_sc_hd__fill_1
X_4261_ clknet_leaf_7_clk _0076_ vssd1 vssd1 vccd1 vccd1 u_core.u_regfile.rf\[31\]\[29\]
+ sky130_fd_sc_hd__dfxtp_1
X_3212_ _1607_ vssd1 vssd1 vccd1 vccd1 _0063_ sky130_fd_sc_hd__clkbuf_1
X_4192_ net359 vssd1 vssd1 vccd1 vccd1 _2096_ sky130_fd_sc_hd__clkbuf_1
XFILLER_0_66_77 vssd1 vssd1 vccd1 vccd1 sky130_fd_sc_hd__decap_4
X_3143_ net499 vssd1 vssd1 vccd1 vccd1 _1564_ sky130_fd_sc_hd__inv_2
X_3074_ u_timer.count_reg\[10\] u_timer.count_reg\[9\] u_timer.count_reg\[8\] _1505_
+ u_timer.count_reg\[11\] vssd1 vssd1 vccd1 vccd1 _1516_ sky130_fd_sc_hd__a41o_1
XFILLER_0_82_65 vccd1 vssd1 vccd1 vssd1 sky130_ef_sc_hd__decap_12
XFILLER_0_17_113 vssd1 vssd1 vccd1 vccd1 sky130_fd_sc_hd__decap_6
X_3976_ net317 vssd1 vssd1 vccd1 vccd1 _1984_ sky130_fd_sc_hd__clkbuf_1
X_2927_ _0782_ _0792_ _0788_ vssd1 vssd1 vccd1 vccd1 _1385_ sky130_fd_sc_hd__nor3_1
XFILLER_0_72_285 vccd1 vssd1 vccd1 vssd1 sky130_ef_sc_hd__decap_12
X_2858_ _0768_ _1302_ _1315_ vssd1 vssd1 vccd1 vccd1 _1316_ sky130_fd_sc_hd__o21a_1
Xhold220 u_core.u_regfile.rf\[25\]\[15\] vssd1 vssd1 vccd1 vccd1 net253 sky130_fd_sc_hd__dlygate4sd3_1
X_2789_ u_core.u_regfile.rf\[29\]\[23\] u_core.u_regfile.rf\[31\]\[23\] _0705_ vssd1
+ vssd1 vccd1 vccd1 _1247_ sky130_fd_sc_hd__mux2_1
Xhold242 u_core.u_regfile.rf\[27\]\[20\] vssd1 vssd1 vccd1 vccd1 net275 sky130_fd_sc_hd__dlygate4sd3_1
Xhold231 u_core.u_regfile.rf\[26\]\[30\] vssd1 vssd1 vccd1 vccd1 net264 sky130_fd_sc_hd__dlygate4sd3_1
Xhold253 u_core.u_regfile.rf\[27\]\[0\] vssd1 vssd1 vccd1 vccd1 net286 sky130_fd_sc_hd__dlygate4sd3_1
X_4528_ clknet_leaf_24_clk _0329_ vssd1 vssd1 vccd1 vccd1 u_core.u_regfile.rf\[2\]\[26\]
+ sky130_fd_sc_hd__dfxtp_1
Xhold264 u_core.u_regfile.rf\[2\]\[30\] vssd1 vssd1 vccd1 vccd1 net297 sky130_fd_sc_hd__dlygate4sd3_1
Xhold286 u_core.u_regfile.rf\[2\]\[29\] vssd1 vssd1 vccd1 vccd1 net319 sky130_fd_sc_hd__dlygate4sd3_1
Xhold275 u_core.u_regfile.rf\[24\]\[3\] vssd1 vssd1 vccd1 vccd1 net308 sky130_fd_sc_hd__dlygate4sd3_1
X_4459_ clknet_leaf_1_clk _0260_ vssd1 vssd1 vccd1 vccd1 u_core.u_regfile.rf\[7\]\[21\]
+ sky130_fd_sc_hd__dfxtp_1
Xhold297 u_core.u_regfile.rf\[25\]\[4\] vssd1 vssd1 vccd1 vccd1 net330 sky130_fd_sc_hd__dlygate4sd3_1
XTAP_580 vssd1 vccd1 sky130_fd_sc_hd__tapvpwrvgnd_1
XTAP_591 vssd1 vccd1 sky130_fd_sc_hd__tapvpwrvgnd_1
XFILLER_0_55_219 vssd1 vssd1 vccd1 vccd1 sky130_fd_sc_hd__decap_4
XFILLER_0_36_477 vssd1 vssd1 vccd1 vccd1 sky130_fd_sc_hd__decap_6
XFILLER_0_63_274 vssd1 vssd1 vccd1 vccd1 sky130_fd_sc_hd__decap_6
XFILLER_0_63_285 vccd1 vssd1 vccd1 vssd1 sky130_ef_sc_hd__decap_12
X_3830_ net164 vssd1 vssd1 vccd1 vccd1 _1911_ sky130_fd_sc_hd__clkbuf_1
XFILLER_0_39_293 vccd1 vssd1 vccd1 vssd1 sky130_ef_sc_hd__decap_12
X_3761_ _0783_ vssd1 vssd1 vccd1 vccd1 _1875_ sky130_fd_sc_hd__clkbuf_4
X_2712_ u_core.u_regfile.rf\[4\]\[16\] _0885_ _0812_ vssd1 vssd1 vccd1 vccd1 _1170_
+ sky130_fd_sc_hd__o21ai_2
X_3692_ _1838_ vssd1 vssd1 vccd1 vccd1 _0312_ sky130_fd_sc_hd__clkbuf_1
X_2643_ _0876_ _0878_ _1099_ _1094_ vssd1 vssd1 vccd1 vccd1 _1101_ sky130_fd_sc_hd__o211ai_4
XFILLER_0_10_300 vssd1 vssd1 vccd1 vccd1 sky130_fd_sc_hd__decap_8
X_2574_ _1030_ _0696_ _0733_ _0903_ _1031_ vssd1 vssd1 vccd1 vccd1 _1032_ sky130_fd_sc_hd__o221ai_1
X_4313_ clknet_leaf_41_clk _0124_ vssd1 vssd1 vccd1 vccd1 u_core.u_regfile.rf\[4\]\[13\]
+ sky130_fd_sc_hd__dfxtp_1
XFILLER_0_50_491 vssd1 vssd1 vccd1 vccd1 sky130_fd_sc_hd__decap_8
X_4244_ clknet_leaf_46_clk _0059_ vssd1 vssd1 vccd1 vccd1 u_core.u_regfile.rf\[31\]\[12\]
+ sky130_fd_sc_hd__dfxtp_1
X_4175_ _2087_ vssd1 vssd1 vccd1 vccd1 _0546_ sky130_fd_sc_hd__clkbuf_1
X_3126_ u_timer.count_reg\[27\] u_timer.count_reg\[26\] _1546_ vssd1 vssd1 vccd1 vccd1
+ _1552_ sky130_fd_sc_hd__and3_1
X_3057_ _1502_ _1495_ _1503_ vssd1 vssd1 vccd1 vccd1 _1504_ sky130_fd_sc_hd__and3b_1
XFILLER_0_77_333 vssd1 vssd1 vccd1 vccd1 sky130_fd_sc_hd__decap_3
XFILLER_0_9_121 vssd1 vssd1 vccd1 vccd1 sky130_fd_sc_hd__decap_3
XFILLER_0_18_444 vssd1 vssd1 vccd1 vccd1 sky130_fd_sc_hd__decap_8
XFILLER_0_80_509 vssd1 vssd1 vccd1 vccd1 sky130_fd_sc_hd__fill_1
X_3959_ _1975_ vssd1 vssd1 vccd1 vccd1 _0442_ sky130_fd_sc_hd__clkbuf_1
XFILLER_0_18_488 vccd1 vssd1 vccd1 vssd1 sky130_ef_sc_hd__decap_12
XFILLER_0_45_274 vssd1 vssd1 vccd1 vccd1 sky130_fd_sc_hd__decap_6
XPHY_50 vssd1 vssd1 vccd1 vccd1 sky130_fd_sc_hd__decap_3
XPHY_61 vssd1 vssd1 vccd1 vccd1 sky130_fd_sc_hd__decap_3
XPHY_72 vssd1 vssd1 vccd1 vccd1 sky130_fd_sc_hd__decap_3
XPHY_83 vssd1 vssd1 vccd1 vccd1 sky130_fd_sc_hd__decap_3
XFILLER_0_22_27 vssd1 vssd1 vccd1 vccd1 sky130_fd_sc_hd__fill_1
XPHY_94 vssd1 vssd1 vccd1 vccd1 sky130_fd_sc_hd__decap_3
XFILLER_0_71_509 vssd1 vssd1 vccd1 vccd1 sky130_fd_sc_hd__fill_1
XFILLER_0_51_200 vssd1 vssd1 vccd1 vccd1 sky130_fd_sc_hd__decap_3
XFILLER_0_24_458 vssd1 vssd1 vccd1 vccd1 sky130_fd_sc_hd__fill_1
XFILLER_0_51_288 vccd1 vssd1 vccd1 vssd1 sky130_ef_sc_hd__decap_12
X_2290_ _0747_ vssd1 vssd1 vccd1 vccd1 _0748_ sky130_fd_sc_hd__buf_6
XFILLER_0_47_57 vssd1 vssd1 vccd1 vccd1 sky130_fd_sc_hd__fill_2
XFILLER_0_2_15 vccd1 vssd1 vccd1 vssd1 sky130_ef_sc_hd__decap_12
XFILLER_0_74_303 vssd1 vssd1 vccd1 vccd1 sky130_fd_sc_hd__decap_4
X_3813_ _1902_ vssd1 vssd1 vccd1 vccd1 _0369_ sky130_fd_sc_hd__clkbuf_1
X_4793_ clknet_leaf_46_clk _0561_ vssd1 vssd1 vccd1 vccd1 u_core.u_regfile.rf\[3\]\[26\]
+ sky130_fd_sc_hd__dfxtp_1
XFILLER_0_6_157 vssd1 vssd1 vccd1 vccd1 sky130_fd_sc_hd__fill_1
X_3744_ _1861_ _1424_ _1865_ vssd1 vssd1 vccd1 vccd1 _0337_ sky130_fd_sc_hd__o21ai_1
X_3675_ net242 vssd1 vssd1 vccd1 vccd1 _1830_ sky130_fd_sc_hd__clkbuf_1
X_2626_ u_core.u_regfile.rf\[1\]\[5\] _0742_ _0808_ _0710_ vssd1 vssd1 vccd1 vccd1
+ _1084_ sky130_fd_sc_hd__o2bb2a_1
XFILLER_0_30_406 vssd1 vssd1 vccd1 vccd1 sky130_fd_sc_hd__decap_3
XFILLER_0_2_363 vssd1 vssd1 vccd1 vccd1 sky130_fd_sc_hd__fill_1
XFILLER_0_10_141 vssd1 vssd1 vccd1 vccd1 sky130_fd_sc_hd__fill_2
X_2557_ _0840_ u_core.u_regfile.rf\[31\]\[3\] vssd1 vssd1 vccd1 vccd1 _1015_ sky130_fd_sc_hd__and2_1
XFILLER_0_56_3 vccd1 vssd1 vccd1 vssd1 sky130_ef_sc_hd__decap_12
XFILLER_0_10_174 vccd1 vssd1 vccd1 vssd1 sky130_ef_sc_hd__decap_12
XFILLER_0_10_163 vssd1 vssd1 vccd1 vccd1 sky130_fd_sc_hd__decap_3
X_2488_ u_core.u_regfile.rf\[29\]\[9\] u_core.u_regfile.rf\[31\]\[9\] _0721_ vssd1
+ vssd1 vccd1 vccd1 _0946_ sky130_fd_sc_hd__mux2_1
X_4227_ _1563_ _1481_ _2113_ vssd1 vssd1 vccd1 vccd1 _0572_ sky130_fd_sc_hd__a21oi_1
X_4158_ net235 vssd1 vssd1 vccd1 vccd1 _2079_ sky130_fd_sc_hd__clkbuf_1
Xmax_cap17 _1130_ vssd1 vssd1 vccd1 vccd1 net17 sky130_fd_sc_hd__buf_1
X_3109_ _1540_ vssd1 vssd1 vccd1 vccd1 _1541_ sky130_fd_sc_hd__clkbuf_2
X_4089_ _2040_ vssd1 vssd1 vccd1 vccd1 _0507_ sky130_fd_sc_hd__clkbuf_1
XFILLER_0_14_491 vssd1 vssd1 vccd1 vccd1 sky130_fd_sc_hd__fill_1
XFILLER_0_17_27 vssd1 vssd1 vccd1 vccd1 sky130_fd_sc_hd__decap_8
XFILLER_0_68_141 vssd1 vssd1 vccd1 vccd1 sky130_fd_sc_hd__decap_3
XFILLER_0_83_111 vssd1 vssd1 vccd1 vccd1 sky130_fd_sc_hd__fill_1
X_3460_ _1705_ _1725_ _1714_ _1726_ _0612_ vssd1 vssd1 vccd1 vccd1 _1729_ sky130_fd_sc_hd__a41o_1
X_2411_ _0812_ _0864_ _0865_ _0868_ vssd1 vssd1 vccd1 vccd1 _0869_ sky130_fd_sc_hd__a31oi_4
X_3391_ _1418_ _1416_ vssd1 vssd1 vccd1 vccd1 _1675_ sky130_fd_sc_hd__nor2_1
XFILLER_0_20_472 vssd1 vssd1 vccd1 vccd1 sky130_fd_sc_hd__decap_4
X_2342_ u_core.u_regfile.rf\[31\]\[27\] _0727_ _0746_ _0716_ _0799_ vssd1 vssd1 vccd1
+ vccd1 _0800_ sky130_fd_sc_hd__o221ai_4
X_2273_ _0730_ vssd1 vssd1 vccd1 vccd1 _0731_ sky130_fd_sc_hd__buf_4
X_4012_ net224 vssd1 vssd1 vccd1 vccd1 _2002_ sky130_fd_sc_hd__clkbuf_1
XFILLER_0_74_77 vssd1 vssd1 vccd1 vccd1 sky130_fd_sc_hd__decap_6
XFILLER_0_79_417 vccd1 vssd1 vccd1 vssd1 sky130_ef_sc_hd__decap_12
XFILLER_0_59_152 vssd1 vssd1 vccd1 vccd1 sky130_fd_sc_hd__decap_3
XFILLER_0_7_422 vssd1 vssd1 vccd1 vccd1 sky130_fd_sc_hd__fill_1
XFILLER_0_35_509 vssd1 vssd1 vccd1 vccd1 sky130_fd_sc_hd__fill_1
X_4776_ clknet_leaf_32_clk _0544_ vssd1 vssd1 vccd1 vccd1 u_core.u_regfile.rf\[3\]\[9\]
+ sky130_fd_sc_hd__dfxtp_1
X_3727_ net246 vssd1 vssd1 vccd1 vccd1 _1856_ sky130_fd_sc_hd__clkbuf_1
XFILLER_0_55_391 vssd1 vssd1 vccd1 vccd1 sky130_fd_sc_hd__fill_1
XFILLER_0_70_372 vssd1 vssd1 vccd1 vccd1 sky130_fd_sc_hd__fill_1
X_3658_ _1821_ vssd1 vssd1 vccd1 vccd1 _0295_ sky130_fd_sc_hd__clkbuf_1
X_3589_ _1791_ _1792_ _1793_ net44 vssd1 vssd1 vccd1 vccd1 _0254_ sky130_fd_sc_hd__o31a_1
X_2609_ _1064_ _1065_ _1051_ _1066_ vssd1 vssd1 vccd1 vccd1 _1067_ sky130_fd_sc_hd__o22ai_1
Xclkbuf_2_2__f_clk clknet_0_clk vssd1 vssd1 vccd1 vccd1 clknet_2_2__leaf_clk sky130_fd_sc_hd__clkbuf_16
XFILLER_0_65_122 vssd1 vssd1 vccd1 vccd1 sky130_fd_sc_hd__fill_1
XFILLER_0_26_509 vssd1 vssd1 vccd1 vccd1 sky130_fd_sc_hd__fill_1
XFILLER_0_65_177 vssd1 vssd1 vccd1 vccd1 sky130_fd_sc_hd__fill_2
XFILLER_0_65_199 vccd1 vssd1 vccd1 vssd1 sky130_ef_sc_hd__decap_12
XFILLER_0_21_269 vssd1 vssd1 vccd1 vccd1 sky130_fd_sc_hd__decap_8
XTAP_409 vssd1 vccd1 sky130_fd_sc_hd__tapvpwrvgnd_1
XFILLER_0_28_15 vccd1 vssd1 vccd1 vssd1 sky130_ef_sc_hd__decap_12
XFILLER_0_28_37 vssd1 vssd1 vccd1 vccd1 sky130_fd_sc_hd__fill_2
X_2960_ _1366_ _1414_ vssd1 vssd1 vccd1 vccd1 _1418_ sky130_fd_sc_hd__xnor2_2
XFILLER_0_56_111 vssd1 vssd1 vccd1 vccd1 sky130_fd_sc_hd__fill_2
XFILLER_0_17_509 vssd1 vssd1 vccd1 vccd1 sky130_fd_sc_hd__fill_1
XFILLER_0_44_306 vssd1 vssd1 vccd1 vccd1 sky130_fd_sc_hd__fill_2
X_2891_ _1347_ _1348_ _1270_ _1344_ vssd1 vssd1 vccd1 vccd1 _1349_ sky130_fd_sc_hd__nor4b_1
XFILLER_0_84_475 vssd1 vssd1 vccd1 vccd1 sky130_fd_sc_hd__fill_1
X_4630_ clknet_leaf_23_clk _0431_ vssd1 vssd1 vccd1 vccd1 u_core.u_regfile.rf\[26\]\[0\]
+ sky130_fd_sc_hd__dfxtp_1
X_4561_ clknet_leaf_18_clk _0362_ vssd1 vssd1 vccd1 vccd1 u_core.u_regfile.rf\[28\]\[27\]
+ sky130_fd_sc_hd__dfxtp_1
X_4492_ clknet_leaf_36_clk _0293_ vssd1 vssd1 vccd1 vccd1 u_core.u_regfile.rf\[30\]\[22\]
+ sky130_fd_sc_hd__dfxtp_1
XFILLER_0_4_469 vssd1 vssd1 vccd1 vccd1 sky130_fd_sc_hd__decap_6
X_3512_ net398 vssd1 vssd1 vccd1 vccd1 _1761_ sky130_fd_sc_hd__clkbuf_1
X_3443_ _1705_ _1706_ _1714_ _1715_ _0628_ vssd1 vssd1 vccd1 vccd1 _1718_ sky130_fd_sc_hd__a41o_1
XTAP_910 vssd1 vccd1 sky130_fd_sc_hd__tapvpwrvgnd_1
XTAP_943 vssd1 vccd1 sky130_fd_sc_hd__tapvpwrvgnd_1
XTAP_932 vssd1 vccd1 sky130_fd_sc_hd__tapvpwrvgnd_1
XTAP_921 vssd1 vccd1 sky130_fd_sc_hd__tapvpwrvgnd_1
X_3374_ _1405_ vssd1 vssd1 vccd1 vccd1 _1671_ sky130_fd_sc_hd__clkbuf_4
XTAP_954 vssd1 vccd1 sky130_fd_sc_hd__tapvpwrvgnd_1
X_2325_ _0746_ vssd1 vssd1 vccd1 vccd1 _0783_ sky130_fd_sc_hd__clkbuf_8
X_2256_ _0713_ vssd1 vssd1 vccd1 vccd1 _0714_ sky130_fd_sc_hd__clkbuf_8
XFILLER_0_79_225 vccd1 vssd1 vccd1 vssd1 sky130_ef_sc_hd__decap_12
X_2187_ u_timer.count_reg\[3\] _0639_ u_timer.count_reg\[2\] _0640_ _0645_ vssd1 vssd1
+ vccd1 vccd1 _0646_ sky130_fd_sc_hd__a221o_1
XFILLER_0_19_3 vccd1 vssd1 vccd1 vssd1 sky130_ef_sc_hd__decap_12
XFILLER_0_67_409 vssd1 vssd1 vccd1 vccd1 sky130_fd_sc_hd__fill_1
XFILLER_0_7_274 vssd1 vssd1 vccd1 vccd1 sky130_fd_sc_hd__decap_3
X_4759_ clknet_leaf_14_clk _0024_ net29 vssd1 vssd1 vccd1 vccd1 u_timer.count_reg\[25\]
+ sky130_fd_sc_hd__dfrtp_2
XFILLER_0_43_350 vccd1 vssd1 vccd1 vssd1 sky130_ef_sc_hd__decap_12
XFILLER_0_50_309 vssd1 vssd1 vccd1 vccd1 sky130_fd_sc_hd__fill_2
XFILLER_0_62_169 vssd1 vssd1 vccd1 vccd1 sky130_fd_sc_hd__decap_8
XFILLER_0_38_111 vssd1 vssd1 vccd1 vccd1 sky130_fd_sc_hd__fill_2
XFILLER_0_38_155 vssd1 vssd1 vccd1 vccd1 sky130_fd_sc_hd__fill_1
XFILLER_0_66_464 vccd1 vssd1 vccd1 vssd1 sky130_ef_sc_hd__decap_12
XFILLER_0_26_328 vssd1 vssd1 vccd1 vccd1 sky130_fd_sc_hd__fill_1
XFILLER_0_53_136 vssd1 vssd1 vccd1 vccd1 sky130_fd_sc_hd__fill_1
XFILLER_0_30_49 vssd1 vssd1 vccd1 vccd1 sky130_fd_sc_hd__fill_1
XFILLER_0_1_417 vccd1 vssd1 vccd1 vssd1 sky130_ef_sc_hd__decap_12
XTAP_206 vssd1 vccd1 sky130_fd_sc_hd__tapvpwrvgnd_1
XTAP_239 vssd1 vccd1 sky130_fd_sc_hd__tapvpwrvgnd_1
XTAP_228 vssd1 vccd1 sky130_fd_sc_hd__tapvpwrvgnd_1
XTAP_217 vssd1 vccd1 sky130_fd_sc_hd__tapvpwrvgnd_1
X_3090_ _0614_ _0613_ _1522_ vssd1 vssd1 vccd1 vccd1 _1528_ sky130_fd_sc_hd__or3b_1
Xhold2 _0040_ vssd1 vssd1 vccd1 vccd1 net35 sky130_fd_sc_hd__dlygate4sd3_1
X_3992_ net357 vssd1 vssd1 vccd1 vccd1 _1992_ sky130_fd_sc_hd__clkbuf_1
XFILLER_0_29_144 vssd1 vssd1 vccd1 vccd1 sky130_fd_sc_hd__fill_1
X_2943_ _1206_ _1400_ _1355_ vssd1 vssd1 vccd1 vccd1 _1401_ sky130_fd_sc_hd__o21ai_1
XFILLER_0_44_103 vssd1 vssd1 vccd1 vccd1 sky130_fd_sc_hd__fill_2
X_2874_ _1316_ _1330_ _1331_ vssd1 vssd1 vccd1 vccd1 _1332_ sky130_fd_sc_hd__o21ai_4
XFILLER_0_72_467 vssd1 vssd1 vccd1 vccd1 sky130_fd_sc_hd__fill_1
XFILLER_0_4_233 vssd1 vssd1 vccd1 vccd1 sky130_fd_sc_hd__decap_6
X_4613_ clknet_leaf_40_clk _0414_ vssd1 vssd1 vccd1 vccd1 u_core.u_regfile.rf\[1\]\[15\]
+ sky130_fd_sc_hd__dfxtp_1
XFILLER_0_32_309 vssd1 vssd1 vccd1 vccd1 sky130_fd_sc_hd__decap_8
XFILLER_0_4_266 vccd1 vssd1 vccd1 vssd1 sky130_ef_sc_hd__decap_12
X_4544_ clknet_leaf_42_clk _0345_ vssd1 vssd1 vccd1 vccd1 u_core.u_regfile.rf\[28\]\[10\]
+ sky130_fd_sc_hd__dfxtp_1
Xhold402 u_core.u_regfile.rf\[4\]\[24\] vssd1 vssd1 vccd1 vccd1 net435 sky130_fd_sc_hd__dlygate4sd3_1
Xhold413 u_timer.count_reg\[5\] vssd1 vssd1 vccd1 vccd1 net446 sky130_fd_sc_hd__dlygate4sd3_1
Xhold435 u_timer.count_reg\[23\] vssd1 vssd1 vccd1 vccd1 net468 sky130_fd_sc_hd__dlygate4sd3_1
Xhold424 u_core.u_regfile.rf\[4\]\[28\] vssd1 vssd1 vccd1 vccd1 net457 sky130_fd_sc_hd__dlygate4sd3_1
Xhold457 u_core.u_regfile.rf\[4\]\[14\] vssd1 vssd1 vccd1 vccd1 net490 sky130_fd_sc_hd__dlygate4sd3_1
Xhold446 u_core.u_regfile.rf\[31\]\[8\] vssd1 vssd1 vccd1 vccd1 net479 sky130_fd_sc_hd__dlygate4sd3_1
X_4475_ clknet_leaf_26_clk _0276_ vssd1 vssd1 vccd1 vccd1 u_core.u_regfile.rf\[30\]\[5\]
+ sky130_fd_sc_hd__dfxtp_1
Xhold468 u_audio.counter\[3\] vssd1 vssd1 vccd1 vccd1 net501 sky130_fd_sc_hd__dlygate4sd3_1
X_3426_ _0634_ _1680_ _1702_ vssd1 vssd1 vccd1 vccd1 _0182_ sky130_fd_sc_hd__a21oi_1
XFILLER_0_0_461 vccd1 vssd1 vccd1 vssd1 sky130_ef_sc_hd__decap_12
Xhold479 u_core.u_regfile.rf\[28\]\[14\] vssd1 vssd1 vccd1 vccd1 net512 sky130_fd_sc_hd__dlygate4sd3_1
X_3357_ _1482_ _1666_ _1667_ net56 vssd1 vssd1 vccd1 vccd1 _0148_ sky130_fd_sc_hd__o31a_1
XTAP_740 vssd1 vccd1 sky130_fd_sc_hd__tapvpwrvgnd_1
XTAP_751 vssd1 vccd1 sky130_fd_sc_hd__tapvpwrvgnd_1
X_2308_ _0717_ _0741_ u_core.u_regfile.rf\[1\]\[29\] _0743_ _0765_ vssd1 vssd1 vccd1
+ vccd1 _0766_ sky130_fd_sc_hd__a221o_2
XTAP_762 vssd1 vccd1 sky130_fd_sc_hd__tapvpwrvgnd_1
XTAP_773 vssd1 vccd1 sky130_fd_sc_hd__tapvpwrvgnd_1
XTAP_784 vssd1 vccd1 sky130_fd_sc_hd__tapvpwrvgnd_1
XTAP_795 vssd1 vccd1 sky130_fd_sc_hd__tapvpwrvgnd_1
X_3288_ net386 vssd1 vssd1 vccd1 vccd1 _1635_ sky130_fd_sc_hd__clkbuf_1
X_2239_ _0696_ vssd1 vssd1 vccd1 vccd1 _0697_ sky130_fd_sc_hd__buf_4
XFILLER_0_0_81 vssd1 vssd1 vccd1 vccd1 sky130_fd_sc_hd__decap_3
XFILLER_0_63_434 vssd1 vssd1 vccd1 vccd1 sky130_fd_sc_hd__decap_3
XFILLER_0_8_3 vccd1 vssd1 vccd1 vssd1 sky130_ef_sc_hd__decap_12
XFILLER_0_58_217 vssd1 vssd1 vccd1 vccd1 sky130_fd_sc_hd__fill_1
XFILLER_0_6_509 vssd1 vssd1 vccd1 vccd1 sky130_fd_sc_hd__fill_1
XFILLER_0_41_15 vssd1 vssd1 vccd1 vccd1 sky130_fd_sc_hd__decap_3
XFILLER_0_14_309 vssd1 vssd1 vccd1 vccd1 sky130_fd_sc_hd__fill_1
XFILLER_0_54_489 vccd1 vssd1 vccd1 vssd1 sky130_ef_sc_hd__decap_12
XFILLER_0_1_225 vccd1 vssd1 vccd1 vssd1 sky130_ef_sc_hd__decap_12
X_2590_ _1041_ _0945_ _1047_ vssd1 vssd1 vccd1 vccd1 _1048_ sky130_fd_sc_hd__a21oi_1
XFILLER_0_5_15 vccd1 vssd1 vccd1 vssd1 sky130_ef_sc_hd__decap_12
X_4260_ clknet_leaf_7_clk _0075_ vssd1 vssd1 vccd1 vccd1 u_core.u_regfile.rf\[31\]\[28\]
+ sky130_fd_sc_hd__dfxtp_1
X_4191_ _2095_ vssd1 vssd1 vccd1 vccd1 _0554_ sky130_fd_sc_hd__clkbuf_1
X_3211_ net534 vssd1 vssd1 vccd1 vccd1 _1607_ sky130_fd_sc_hd__clkbuf_1
X_3142_ net478 vssd1 vssd1 vccd1 vccd1 _1563_ sky130_fd_sc_hd__inv_2
XFILLER_0_66_56 vssd1 vssd1 vccd1 vccd1 sky130_fd_sc_hd__fill_1
X_3073_ u_timer.count_reg\[11\] u_timer.count_reg\[10\] _1509_ vssd1 vssd1 vccd1 vccd1
+ _1515_ sky130_fd_sc_hd__and3_1
XFILLER_0_82_77 vssd1 vssd1 vccd1 vccd1 sky130_fd_sc_hd__decap_6
XFILLER_0_45_412 vccd1 vssd1 vccd1 vssd1 sky130_ef_sc_hd__decap_12
X_3975_ _1983_ vssd1 vssd1 vccd1 vccd1 _0450_ sky130_fd_sc_hd__clkbuf_1
X_2926_ _0782_ _0788_ _0792_ vssd1 vssd1 vccd1 vccd1 _1384_ sky130_fd_sc_hd__o21a_1
XFILLER_0_72_264 vssd1 vssd1 vccd1 vccd1 sky130_fd_sc_hd__fill_1
XFILLER_0_72_242 vssd1 vssd1 vccd1 vccd1 sky130_fd_sc_hd__decap_6
X_2857_ _1313_ _1314_ vssd1 vssd1 vccd1 vccd1 _1315_ sky130_fd_sc_hd__nor2_1
XFILLER_0_72_297 vssd1 vssd1 vccd1 vccd1 sky130_fd_sc_hd__decap_8
Xhold210 u_core.u_regfile.rf\[2\]\[20\] vssd1 vssd1 vccd1 vccd1 net243 sky130_fd_sc_hd__dlygate4sd3_1
X_2788_ u_core.u_regfile.rf\[5\]\[23\] _0876_ _0904_ _0952_ _0773_ vssd1 vssd1 vccd1
+ vccd1 _1246_ sky130_fd_sc_hd__o32a_1
Xhold221 u_core.u_regfile.rf\[25\]\[14\] vssd1 vssd1 vccd1 vccd1 net254 sky130_fd_sc_hd__dlygate4sd3_1
XFILLER_0_13_364 vccd1 vssd1 vccd1 vssd1 sky130_ef_sc_hd__decap_12
Xhold232 u_core.u_regfile.rf\[2\]\[8\] vssd1 vssd1 vccd1 vccd1 net265 sky130_fd_sc_hd__dlygate4sd3_1
X_4527_ clknet_leaf_27_clk _0328_ vssd1 vssd1 vccd1 vccd1 u_core.u_regfile.rf\[2\]\[25\]
+ sky130_fd_sc_hd__dfxtp_1
Xhold243 u_core.u_regfile.rf\[25\]\[6\] vssd1 vssd1 vccd1 vccd1 net276 sky130_fd_sc_hd__dlygate4sd3_1
Xhold276 u_core.u_regfile.rf\[25\]\[16\] vssd1 vssd1 vccd1 vccd1 net309 sky130_fd_sc_hd__dlygate4sd3_1
X_4458_ clknet_leaf_1_clk _0259_ vssd1 vssd1 vccd1 vccd1 u_core.u_regfile.rf\[7\]\[20\]
+ sky130_fd_sc_hd__dfxtp_1
Xhold265 u_core.u_regfile.rf\[27\]\[15\] vssd1 vssd1 vccd1 vccd1 net298 sky130_fd_sc_hd__dlygate4sd3_1
Xhold287 u_core.u_regfile.rf\[25\]\[25\] vssd1 vssd1 vccd1 vccd1 net320 sky130_fd_sc_hd__dlygate4sd3_1
Xhold254 u_core.u_regfile.rf\[30\]\[21\] vssd1 vssd1 vccd1 vccd1 net287 sky130_fd_sc_hd__dlygate4sd3_1
Xhold298 u_core.u_regfile.rf\[25\]\[19\] vssd1 vssd1 vccd1 vccd1 net331 sky130_fd_sc_hd__dlygate4sd3_1
X_3409_ _1051_ _1057_ _1678_ _1683_ _1686_ vssd1 vssd1 vccd1 vccd1 _1691_ sky130_fd_sc_hd__o2111a_1
XTAP_570 vssd1 vccd1 sky130_fd_sc_hd__tapvpwrvgnd_1
X_4389_ clknet_leaf_16_clk _0200_ net27 vssd1 vssd1 vccd1 vccd1 u_timer.threshold_reg\[25\]
+ sky130_fd_sc_hd__dfrtp_1
XTAP_581 vssd1 vccd1 sky130_fd_sc_hd__tapvpwrvgnd_1
XTAP_592 vssd1 vccd1 sky130_fd_sc_hd__tapvpwrvgnd_1
XFILLER_0_36_456 vssd1 vssd1 vccd1 vccd1 sky130_fd_sc_hd__fill_2
XFILLER_0_63_297 vccd1 vssd1 vccd1 vssd1 sky130_ef_sc_hd__decap_12
XFILLER_0_27_401 vssd1 vssd1 vccd1 vccd1 sky130_fd_sc_hd__fill_1
X_3760_ _1874_ vssd1 vssd1 vccd1 vccd1 _0344_ sky130_fd_sc_hd__clkbuf_1
X_2711_ _0754_ u_core.u_regfile.rf\[7\]\[16\] _0714_ vssd1 vssd1 vccd1 vccd1 _1169_
+ sky130_fd_sc_hd__nand3_2
X_3691_ net352 vssd1 vssd1 vccd1 vccd1 _1838_ sky130_fd_sc_hd__clkbuf_1
XFILLER_0_42_415 vssd1 vssd1 vccd1 vccd1 sky130_fd_sc_hd__decap_4
XFILLER_0_2_501 vssd1 vssd1 vccd1 vccd1 sky130_fd_sc_hd__decap_8
X_2642_ _1094_ _0965_ _1099_ vssd1 vssd1 vccd1 vccd1 _1100_ sky130_fd_sc_hd__a21o_1
X_2573_ _0757_ _0740_ u_core.u_regfile.rf\[28\]\[0\] vssd1 vssd1 vccd1 vccd1 _1031_
+ sky130_fd_sc_hd__o21ai_1
XFILLER_0_77_55 vssd1 vssd1 vccd1 vccd1 sky130_fd_sc_hd__fill_1
XFILLER_0_10_334 vssd1 vssd1 vccd1 vccd1 sky130_fd_sc_hd__fill_2
X_4312_ clknet_leaf_46_clk _0123_ vssd1 vssd1 vccd1 vccd1 u_core.u_regfile.rf\[4\]\[12\]
+ sky130_fd_sc_hd__dfxtp_1
XFILLER_0_10_378 vssd1 vssd1 vccd1 vccd1 sky130_fd_sc_hd__fill_1
X_4243_ clknet_leaf_31_clk _0058_ vssd1 vssd1 vccd1 vccd1 u_core.u_regfile.rf\[31\]\[11\]
+ sky130_fd_sc_hd__dfxtp_1
X_4174_ net362 vssd1 vssd1 vccd1 vccd1 _2087_ sky130_fd_sc_hd__clkbuf_1
X_3125_ _1551_ vssd1 vssd1 vccd1 vccd1 _0025_ sky130_fd_sc_hd__clkbuf_1
X_3056_ u_timer.count_reg\[5\] u_timer.count_reg\[4\] _1494_ u_timer.count_reg\[6\]
+ vssd1 vssd1 vccd1 vccd1 _1503_ sky130_fd_sc_hd__a31o_1
XFILLER_0_18_434 vssd1 vssd1 vccd1 vccd1 sky130_fd_sc_hd__fill_2
X_3958_ net184 vssd1 vssd1 vccd1 vccd1 _1975_ sky130_fd_sc_hd__clkbuf_1
X_3889_ _1940_ vssd1 vssd1 vccd1 vccd1 _0407_ sky130_fd_sc_hd__clkbuf_1
X_2909_ _1151_ _1366_ _1008_ vssd1 vssd1 vccd1 vccd1 _1367_ sky130_fd_sc_hd__o21bai_4
XFILLER_0_13_194 vssd1 vssd1 vccd1 vccd1 sky130_fd_sc_hd__fill_2
XFILLER_0_13_183 vssd1 vssd1 vccd1 vccd1 sky130_fd_sc_hd__decap_4
XPHY_40 vssd1 vssd1 vccd1 vccd1 sky130_fd_sc_hd__decap_3
XFILLER_0_68_345 vccd1 vssd1 vccd1 vssd1 sky130_ef_sc_hd__decap_12
XPHY_51 vssd1 vssd1 vccd1 vccd1 sky130_fd_sc_hd__decap_3
XPHY_62 vssd1 vssd1 vccd1 vccd1 sky130_fd_sc_hd__decap_3
XPHY_73 vssd1 vssd1 vccd1 vccd1 sky130_fd_sc_hd__decap_3
XFILLER_0_83_337 vccd1 vssd1 vccd1 vssd1 sky130_ef_sc_hd__decap_12
XPHY_84 vssd1 vssd1 vccd1 vccd1 sky130_fd_sc_hd__decap_3
XPHY_95 vssd1 vssd1 vccd1 vccd1 sky130_fd_sc_hd__decap_3
XFILLER_0_36_253 vssd1 vssd1 vccd1 vccd1 sky130_fd_sc_hd__decap_4
XFILLER_0_24_448 vssd1 vssd1 vccd1 vccd1 sky130_fd_sc_hd__decap_3
XFILLER_0_32_481 vssd1 vssd1 vccd1 vccd1 sky130_fd_sc_hd__fill_1
XFILLER_0_47_47 vssd1 vssd1 vccd1 vccd1 sky130_fd_sc_hd__decap_3
XFILLER_0_78_109 vssd1 vssd1 vccd1 vccd1 sky130_fd_sc_hd__fill_1
XFILLER_0_2_27 vssd1 vssd1 vccd1 vccd1 sky130_fd_sc_hd__fill_1
XFILLER_0_63_57 vssd1 vssd1 vccd1 vccd1 sky130_fd_sc_hd__fill_1
XFILLER_0_59_378 vssd1 vssd1 vccd1 vccd1 sky130_fd_sc_hd__decap_8
X_3812_ net270 vssd1 vssd1 vccd1 vccd1 _1902_ sky130_fd_sc_hd__clkbuf_1
X_4792_ clknet_leaf_24_clk _0560_ vssd1 vssd1 vccd1 vccd1 u_core.u_regfile.rf\[3\]\[25\]
+ sky130_fd_sc_hd__dfxtp_1
XFILLER_0_15_426 vssd1 vssd1 vccd1 vccd1 sky130_fd_sc_hd__decap_4
X_3743_ _1674_ _1862_ net41 vssd1 vssd1 vccd1 vccd1 _1865_ sky130_fd_sc_hd__o21ai_1
X_3674_ _1829_ vssd1 vssd1 vccd1 vccd1 _0303_ sky130_fd_sc_hd__clkbuf_1
XFILLER_0_27_297 vssd1 vssd1 vccd1 vccd1 sky130_fd_sc_hd__fill_2
X_2625_ _0745_ _0748_ _0885_ u_core.u_regfile.rf\[4\]\[5\] _1082_ vssd1 vssd1 vccd1
+ vccd1 _1083_ sky130_fd_sc_hd__o221ai_4
X_2556_ u_core.u_regfile.rf\[1\]\[3\] _0742_ _1012_ _1013_ _0914_ vssd1 vssd1 vccd1
+ vccd1 _1014_ sky130_fd_sc_hd__a221oi_4
XFILLER_0_10_186 vssd1 vssd1 vccd1 vccd1 sky130_fd_sc_hd__decap_4
X_2487_ _0705_ _0714_ _0710_ vssd1 vssd1 vccd1 vccd1 _0945_ sky130_fd_sc_hd__and3_1
XFILLER_0_49_3 vccd1 vssd1 vccd1 vssd1 sky130_ef_sc_hd__decap_12
X_4226_ _1697_ _1698_ net12 _1694_ _1695_ vssd1 vssd1 vccd1 vccd1 _2113_ sky130_fd_sc_hd__o2111a_1
X_4157_ _2078_ vssd1 vssd1 vccd1 vccd1 _0537_ sky130_fd_sc_hd__clkbuf_1
X_3108_ u_timer.count_reg\[21\] u_timer.count_reg\[20\] u_timer.count_reg\[19\] _1536_
+ vssd1 vssd1 vccd1 vccd1 _1540_ sky130_fd_sc_hd__and4_1
Xmax_cap18 _1113_ vssd1 vssd1 vccd1 vccd1 net18 sky130_fd_sc_hd__buf_1
X_4088_ net351 vssd1 vssd1 vccd1 vccd1 _2040_ sky130_fd_sc_hd__clkbuf_1
X_3039_ u_timer.count_reg\[1\] u_timer.count_reg\[0\] _1490_ vssd1 vssd1 vccd1 vccd1
+ _1491_ sky130_fd_sc_hd__o21ai_1
XFILLER_0_77_164 vssd1 vssd1 vccd1 vccd1 sky130_fd_sc_hd__decap_4
XFILLER_0_77_197 vssd1 vssd1 vccd1 vccd1 sky130_fd_sc_hd__fill_1
XFILLER_0_65_337 vssd1 vssd1 vccd1 vccd1 sky130_fd_sc_hd__decap_4
XFILLER_0_65_348 vccd1 vssd1 vccd1 vssd1 sky130_ef_sc_hd__decap_12
XFILLER_0_18_253 vssd1 vssd1 vccd1 vccd1 sky130_fd_sc_hd__fill_2
XFILLER_0_83_167 vssd1 vssd1 vccd1 vccd1 sky130_fd_sc_hd__fill_1
XFILLER_0_56_359 vssd1 vssd1 vccd1 vccd1 sky130_fd_sc_hd__decap_4
XFILLER_0_64_392 vssd1 vssd1 vccd1 vccd1 sky130_fd_sc_hd__fill_1
X_2410_ _0866_ u_core.u_regfile.rf\[1\]\[14\] _0857_ _0867_ vssd1 vssd1 vccd1 vccd1
+ _0868_ sky130_fd_sc_hd__a31o_1
X_3390_ _1405_ _1674_ _0898_ net79 vssd1 vssd1 vccd1 vccd1 _0174_ sky130_fd_sc_hd__o31a_1
XFILLER_0_58_46 vccd1 vssd1 vccd1 vssd1 sky130_ef_sc_hd__decap_12
X_2341_ _0743_ _0797_ _0798_ vssd1 vssd1 vccd1 vccd1 _0799_ sky130_fd_sc_hd__o21ai_2
X_2272_ _0729_ vssd1 vssd1 vccd1 vccd1 _0730_ sky130_fd_sc_hd__clkbuf_4
X_4011_ _2001_ vssd1 vssd1 vccd1 vccd1 _0468_ sky130_fd_sc_hd__clkbuf_1
XFILLER_0_79_429 vccd1 vssd1 vccd1 vssd1 sky130_ef_sc_hd__decap_12
XFILLER_0_47_337 vccd1 vssd1 vccd1 vssd1 sky130_ef_sc_hd__decap_12
XFILLER_0_59_197 vssd1 vssd1 vccd1 vccd1 sky130_fd_sc_hd__decap_3
X_4775_ clknet_leaf_28_clk _0543_ vssd1 vssd1 vccd1 vccd1 u_core.u_regfile.rf\[3\]\[8\]
+ sky130_fd_sc_hd__dfxtp_1
X_3726_ _1855_ vssd1 vssd1 vccd1 vccd1 _0329_ sky130_fd_sc_hd__clkbuf_1
X_3657_ net324 vssd1 vssd1 vccd1 vccd1 _1821_ sky130_fd_sc_hd__clkbuf_1
X_3588_ _1791_ _1792_ _1793_ net106 vssd1 vssd1 vccd1 vccd1 _0253_ sky130_fd_sc_hd__o31a_1
X_2608_ _0876_ _0878_ _1052_ _1056_ vssd1 vssd1 vccd1 vccd1 _1066_ sky130_fd_sc_hd__o22ai_1
X_2539_ _0987_ _0988_ _0996_ _0734_ vssd1 vssd1 vccd1 vccd1 _0997_ sky130_fd_sc_hd__a22oi_4
XFILLER_0_48_90 vssd1 vssd1 vccd1 vccd1 sky130_fd_sc_hd__fill_1
X_4209_ _2104_ vssd1 vssd1 vccd1 vccd1 _0563_ sky130_fd_sc_hd__clkbuf_1
XFILLER_0_0_109 vssd1 vssd1 vccd1 vccd1 sky130_fd_sc_hd__decap_3
XFILLER_0_28_27 vssd1 vssd1 vccd1 vccd1 sky130_fd_sc_hd__fill_1
XFILLER_0_44_15 vccd1 vssd1 vccd1 vssd1 sky130_ef_sc_hd__decap_12
XFILLER_0_84_421 vccd1 vssd1 vccd1 vssd1 sky130_ef_sc_hd__decap_12
X_2890_ _1249_ _1246_ _1346_ vssd1 vssd1 vccd1 vccd1 _1348_ sky130_fd_sc_hd__a21oi_1
XFILLER_0_56_178 vssd1 vssd1 vccd1 vccd1 sky130_fd_sc_hd__fill_1
XFILLER_0_4_404 vssd1 vssd1 vccd1 vccd1 sky130_fd_sc_hd__decap_8
X_4560_ clknet_leaf_19_clk _0361_ vssd1 vssd1 vccd1 vccd1 u_core.u_regfile.rf\[28\]\[26\]
+ sky130_fd_sc_hd__dfxtp_1
XFILLER_0_8_15 vccd1 vssd1 vccd1 vssd1 sky130_ef_sc_hd__decap_12
X_3511_ _1760_ vssd1 vssd1 vccd1 vccd1 _0209_ sky130_fd_sc_hd__clkbuf_1
X_4491_ clknet_leaf_24_clk _0292_ vssd1 vssd1 vccd1 vccd1 u_core.u_regfile.rf\[30\]\[21\]
+ sky130_fd_sc_hd__dfxtp_1
X_3442_ u_core.u_regfile.rf\[31\]\[9\] _1483_ _0783_ _1405_ _0944_ vssd1 vssd1 vccd1
+ vccd1 _1717_ sky130_fd_sc_hd__o221ai_4
XTAP_900 vssd1 vccd1 sky130_fd_sc_hd__tapvpwrvgnd_1
X_3373_ _1668_ _1669_ _1670_ net85 vssd1 vssd1 vccd1 vccd1 _0161_ sky130_fd_sc_hd__o31a_1
XFILLER_0_85_44 vccd1 vssd1 vccd1 vssd1 sky130_ef_sc_hd__decap_12
XTAP_944 vssd1 vccd1 sky130_fd_sc_hd__tapvpwrvgnd_1
XTAP_933 vssd1 vccd1 sky130_fd_sc_hd__tapvpwrvgnd_1
XTAP_922 vssd1 vccd1 sky130_fd_sc_hd__tapvpwrvgnd_1
XTAP_911 vssd1 vccd1 sky130_fd_sc_hd__tapvpwrvgnd_1
X_2324_ _0781_ vssd1 vssd1 vccd1 vccd1 _0782_ sky130_fd_sc_hd__clkbuf_4
XTAP_955 vssd1 vccd1 sky130_fd_sc_hd__tapvpwrvgnd_1
X_2255_ _0688_ vssd1 vssd1 vccd1 vccd1 _0713_ sky130_fd_sc_hd__clkbuf_4
X_2186_ _0642_ _0644_ u_timer.count_reg\[2\] _0640_ vssd1 vssd1 vccd1 vccd1 _0645_
+ sky130_fd_sc_hd__o2bb2a_1
XFILLER_0_79_237 vccd1 vssd1 vccd1 vssd1 sky130_ef_sc_hd__decap_12
XFILLER_0_47_156 vssd1 vssd1 vccd1 vccd1 sky130_fd_sc_hd__fill_2
X_4758_ clknet_leaf_14_clk _0023_ net29 vssd1 vssd1 vccd1 vccd1 u_timer.count_reg\[24\]
+ sky130_fd_sc_hd__dfrtp_4
XFILLER_0_43_362 vssd1 vssd1 vccd1 vccd1 sky130_fd_sc_hd__decap_3
X_4689_ clknet_leaf_33_clk _0490_ vssd1 vssd1 vccd1 vccd1 u_core.u_regfile.rf\[24\]\[27\]
+ sky130_fd_sc_hd__dfxtp_1
XFILLER_0_43_384 vssd1 vssd1 vccd1 vccd1 sky130_fd_sc_hd__decap_8
X_3709_ net305 vssd1 vssd1 vccd1 vccd1 _1847_ sky130_fd_sc_hd__clkbuf_1
XFILLER_0_38_134 vssd1 vssd1 vccd1 vccd1 sky130_fd_sc_hd__decap_6
XFILLER_0_1_429 vccd1 vssd1 vccd1 vssd1 sky130_ef_sc_hd__decap_12
XFILLER_0_39_15 vssd1 vssd1 vccd1 vccd1 sky130_fd_sc_hd__decap_6
XTAP_229 vssd1 vccd1 sky130_fd_sc_hd__tapvpwrvgnd_1
XTAP_207 vssd1 vccd1 sky130_fd_sc_hd__tapvpwrvgnd_1
XTAP_218 vssd1 vccd1 sky130_fd_sc_hd__tapvpwrvgnd_1
Xhold3 u_audio.counter\[2\] vssd1 vssd1 vccd1 vccd1 net36 sky130_fd_sc_hd__dlygate4sd3_1
XFILLER_0_55_47 vssd1 vssd1 vccd1 vccd1 sky130_fd_sc_hd__decap_3
X_3991_ _1991_ vssd1 vssd1 vccd1 vccd1 _0458_ sky130_fd_sc_hd__clkbuf_1
XFILLER_0_69_270 vssd1 vssd1 vccd1 vccd1 sky130_fd_sc_hd__decap_3
XFILLER_0_69_281 vssd1 vssd1 vccd1 vccd1 sky130_fd_sc_hd__fill_1
XFILLER_0_71_57 vccd1 vssd1 vccd1 vssd1 sky130_ef_sc_hd__decap_12
X_2942_ _1190_ _1191_ _1399_ _1395_ vssd1 vssd1 vccd1 vccd1 _1400_ sky130_fd_sc_hd__o22ai_2
XFILLER_0_29_167 vssd1 vssd1 vccd1 vccd1 sky130_fd_sc_hd__fill_1
X_2873_ _1313_ _1316_ _1328_ vssd1 vssd1 vccd1 vccd1 _1331_ sky130_fd_sc_hd__o21bai_2
X_4612_ clknet_leaf_46_clk _0413_ vssd1 vssd1 vccd1 vccd1 u_core.u_regfile.rf\[1\]\[14\]
+ sky130_fd_sc_hd__dfxtp_1
X_4543_ clknet_leaf_43_clk _0344_ vssd1 vssd1 vccd1 vccd1 u_core.u_regfile.rf\[28\]\[9\]
+ sky130_fd_sc_hd__dfxtp_1
Xhold436 _0022_ vssd1 vssd1 vccd1 vccd1 net469 sky130_fd_sc_hd__dlygate4sd3_1
Xhold425 u_core.u_regfile.rf\[1\]\[7\] vssd1 vssd1 vccd1 vccd1 net458 sky130_fd_sc_hd__dlygate4sd3_1
XFILLER_0_4_278 vccd1 vssd1 vccd1 vssd1 sky130_ef_sc_hd__decap_12
XFILLER_0_20_83 vssd1 vssd1 vccd1 vccd1 sky130_fd_sc_hd__fill_1
Xhold414 u_core.u_regfile.rf\[31\]\[4\] vssd1 vssd1 vccd1 vccd1 net447 sky130_fd_sc_hd__dlygate4sd3_1
Xhold403 u_core.u_regfile.rf\[29\]\[26\] vssd1 vssd1 vccd1 vccd1 net436 sky130_fd_sc_hd__dlygate4sd3_1
Xhold447 u_core.u_regfile.rf\[1\]\[9\] vssd1 vssd1 vccd1 vccd1 net480 sky130_fd_sc_hd__dlygate4sd3_1
Xhold458 u_core.u_regfile.rf\[4\]\[2\] vssd1 vssd1 vccd1 vccd1 net491 sky130_fd_sc_hd__dlygate4sd3_1
XFILLER_0_40_365 vccd1 vssd1 vccd1 vssd1 sky130_ef_sc_hd__decap_12
Xhold469 u_core.u_regfile.rf\[1\]\[16\] vssd1 vssd1 vccd1 vccd1 net502 sky130_fd_sc_hd__dlygate4sd3_1
X_4474_ clknet_leaf_27_clk _0275_ vssd1 vssd1 vccd1 vccd1 u_core.u_regfile.rf\[30\]\[4\]
+ sky130_fd_sc_hd__dfxtp_1
XFILLER_0_0_473 vssd1 vssd1 vccd1 vccd1 sky130_fd_sc_hd__decap_3
X_3425_ _1134_ _1135_ _1678_ _1694_ _1695_ vssd1 vssd1 vccd1 vccd1 _1702_ sky130_fd_sc_hd__o2111a_1
X_3356_ _1482_ _1666_ _1667_ net62 vssd1 vssd1 vccd1 vccd1 _0147_ sky130_fd_sc_hd__o31a_1
XTAP_730 vssd1 vccd1 sky130_fd_sc_hd__tapvpwrvgnd_1
XTAP_741 vssd1 vccd1 sky130_fd_sc_hd__tapvpwrvgnd_1
XTAP_752 vssd1 vccd1 sky130_fd_sc_hd__tapvpwrvgnd_1
X_3287_ _1634_ vssd1 vssd1 vccd1 vccd1 _0111_ sky130_fd_sc_hd__clkbuf_1
XFILLER_0_29_81 vssd1 vssd1 vccd1 vccd1 sky130_fd_sc_hd__fill_2
X_2307_ _0746_ _0748_ _0751_ u_core.u_regfile.rf\[4\]\[29\] _0764_ vssd1 vssd1 vccd1
+ vccd1 _0765_ sky130_fd_sc_hd__o221a_1
XTAP_763 vssd1 vccd1 sky130_fd_sc_hd__tapvpwrvgnd_1
XTAP_774 vssd1 vccd1 sky130_fd_sc_hd__tapvpwrvgnd_1
XTAP_785 vssd1 vccd1 sky130_fd_sc_hd__tapvpwrvgnd_1
X_2238_ _0688_ _0695_ vssd1 vssd1 vccd1 vccd1 _0696_ sky130_fd_sc_hd__nand2_4
XFILLER_0_31_3 vssd1 vssd1 vccd1 vccd1 sky130_fd_sc_hd__decap_6
XTAP_796 vssd1 vccd1 sky130_fd_sc_hd__tapvpwrvgnd_1
X_2169_ net553 vssd1 vssd1 vccd1 vccd1 _0628_ sky130_fd_sc_hd__inv_2
XFILLER_0_48_465 vssd1 vssd1 vccd1 vccd1 sky130_fd_sc_hd__fill_1
XFILLER_0_16_351 vssd1 vssd1 vccd1 vccd1 sky130_fd_sc_hd__fill_2
XFILLER_0_66_251 vssd1 vssd1 vccd1 vccd1 sky130_fd_sc_hd__fill_1
XFILLER_0_26_137 vssd1 vssd1 vccd1 vccd1 sky130_fd_sc_hd__decap_3
XFILLER_0_66_284 vssd1 vssd1 vccd1 vccd1 sky130_fd_sc_hd__fill_1
XFILLER_0_81_265 vssd1 vssd1 vccd1 vccd1 sky130_fd_sc_hd__fill_2
XFILLER_0_1_237 vccd1 vssd1 vccd1 vssd1 sky130_ef_sc_hd__decap_12
XFILLER_0_5_27 vssd1 vssd1 vccd1 vccd1 sky130_fd_sc_hd__decap_4
XFILLER_0_5_49 vssd1 vssd1 vccd1 vccd1 sky130_fd_sc_hd__fill_1
X_4190_ net137 vssd1 vssd1 vccd1 vccd1 _2095_ sky130_fd_sc_hd__clkbuf_1
XFILLER_0_5_38 vssd1 vssd1 vccd1 vccd1 sky130_fd_sc_hd__decap_3
X_3210_ _1606_ vssd1 vssd1 vccd1 vccd1 _0062_ sky130_fd_sc_hd__clkbuf_1
X_3141_ net503 vssd1 vssd1 vccd1 vccd1 _1562_ sky130_fd_sc_hd__inv_2
X_3072_ _1514_ vssd1 vssd1 vccd1 vccd1 _0008_ sky130_fd_sc_hd__clkbuf_1
XFILLER_0_77_505 vssd1 vssd1 vccd1 vccd1 sky130_fd_sc_hd__decap_4
XFILLER_0_49_207 vssd1 vssd1 vccd1 vccd1 sky130_fd_sc_hd__decap_6
XFILLER_0_17_104 vssd1 vssd1 vccd1 vccd1 sky130_fd_sc_hd__decap_8
X_3974_ net230 vssd1 vssd1 vccd1 vccd1 _1983_ sky130_fd_sc_hd__clkbuf_1
XFILLER_0_45_424 vssd1 vssd1 vccd1 vccd1 sky130_fd_sc_hd__decap_4
XFILLER_0_45_435 vccd1 vssd1 vccd1 vssd1 sky130_ef_sc_hd__decap_12
X_2925_ _1364_ _1369_ _1375_ _1379_ _1382_ vssd1 vssd1 vccd1 vccd1 _1383_ sky130_fd_sc_hd__o2111a_1
X_2856_ _0782_ _1308_ _1312_ vssd1 vssd1 vccd1 vccd1 _1314_ sky130_fd_sc_hd__o21ba_1
XFILLER_0_79_3 vccd1 vssd1 vccd1 vssd1 sky130_ef_sc_hd__decap_12
Xhold200 u_core.u_regfile.rf\[2\]\[31\] vssd1 vssd1 vccd1 vccd1 net233 sky130_fd_sc_hd__dlygate4sd3_1
Xhold211 u_core.u_regfile.rf\[30\]\[2\] vssd1 vssd1 vccd1 vccd1 net244 sky130_fd_sc_hd__dlygate4sd3_1
X_2787_ _1242_ _1243_ _1244_ vssd1 vssd1 vccd1 vccd1 _1245_ sky130_fd_sc_hd__a21oi_2
X_4526_ clknet_leaf_46_clk _0327_ vssd1 vssd1 vccd1 vccd1 u_core.u_regfile.rf\[2\]\[24\]
+ sky130_fd_sc_hd__dfxtp_1
Xhold222 u_core.u_regfile.rf\[5\]\[8\] vssd1 vssd1 vccd1 vccd1 net255 sky130_fd_sc_hd__dlygate4sd3_1
Xhold233 u_core.u_regfile.rf\[26\]\[2\] vssd1 vssd1 vccd1 vccd1 net266 sky130_fd_sc_hd__dlygate4sd3_1
Xhold244 u_core.u_regfile.rf\[26\]\[27\] vssd1 vssd1 vccd1 vccd1 net277 sky130_fd_sc_hd__dlygate4sd3_1
Xhold277 u_core.u_regfile.rf\[26\]\[26\] vssd1 vssd1 vccd1 vccd1 net310 sky130_fd_sc_hd__dlygate4sd3_1
X_4457_ clknet_leaf_1_clk _0258_ vssd1 vssd1 vccd1 vccd1 u_core.u_regfile.rf\[7\]\[19\]
+ sky130_fd_sc_hd__dfxtp_1
Xhold255 u_core.u_regfile.rf\[2\]\[0\] vssd1 vssd1 vccd1 vccd1 net288 sky130_fd_sc_hd__dlygate4sd3_1
Xhold266 u_core.u_regfile.rf\[26\]\[8\] vssd1 vssd1 vccd1 vccd1 net299 sky130_fd_sc_hd__dlygate4sd3_1
Xhold299 u_core.u_regfile.rf\[27\]\[28\] vssd1 vssd1 vccd1 vccd1 net332 sky130_fd_sc_hd__dlygate4sd3_1
XFILLER_0_0_281 vccd1 vssd1 vccd1 vssd1 sky130_ef_sc_hd__decap_12
Xhold288 u_core.u_regfile.rf\[27\]\[27\] vssd1 vssd1 vccd1 vccd1 net321 sky130_fd_sc_hd__dlygate4sd3_1
X_3408_ _0641_ _1680_ _1690_ vssd1 vssd1 vccd1 vccd1 _0176_ sky130_fd_sc_hd__a21oi_1
XTAP_560 vssd1 vccd1 sky130_fd_sc_hd__tapvpwrvgnd_1
X_4388_ clknet_leaf_15_clk _0199_ net28 vssd1 vssd1 vccd1 vccd1 u_timer.threshold_reg\[24\]
+ sky130_fd_sc_hd__dfrtp_1
X_3339_ _1660_ vssd1 vssd1 vccd1 vccd1 _0137_ sky130_fd_sc_hd__clkbuf_1
XTAP_571 vssd1 vccd1 sky130_fd_sc_hd__tapvpwrvgnd_1
XTAP_582 vssd1 vccd1 sky130_fd_sc_hd__tapvpwrvgnd_1
XTAP_593 vssd1 vccd1 sky130_fd_sc_hd__tapvpwrvgnd_1
XFILLER_0_59_505 vssd1 vssd1 vccd1 vccd1 sky130_fd_sc_hd__decap_4
XFILLER_0_52_15 vccd1 vssd1 vccd1 vssd1 sky130_ef_sc_hd__decap_12
X_2710_ _0808_ _0761_ u_core.u_regfile.rf\[6\]\[16\] vssd1 vssd1 vccd1 vccd1 _1168_
+ sky130_fd_sc_hd__o21ai_1
X_3690_ _1837_ vssd1 vssd1 vccd1 vccd1 _0311_ sky130_fd_sc_hd__clkbuf_1
X_2641_ _0952_ _0773_ _0693_ u_core.u_regfile.rf\[5\]\[4\] _1098_ vssd1 vssd1 vccd1
+ vccd1 _1099_ sky130_fd_sc_hd__o221a_1
X_2572_ _0685_ u_core.u_regfile.rf\[29\]\[0\] _1029_ vssd1 vssd1 vccd1 vccd1 _1030_
+ sky130_fd_sc_hd__a21boi_1
X_4311_ clknet_leaf_40_clk _0122_ vssd1 vssd1 vccd1 vccd1 u_core.u_regfile.rf\[4\]\[11\]
+ sky130_fd_sc_hd__dfxtp_1
XFILLER_0_22_173 vssd1 vssd1 vccd1 vccd1 sky130_fd_sc_hd__fill_2
XFILLER_0_65_9 vccd1 vssd1 vccd1 vssd1 sky130_ef_sc_hd__decap_12
X_4242_ clknet_leaf_42_clk _0057_ vssd1 vssd1 vccd1 vccd1 u_core.u_regfile.rf\[31\]\[10\]
+ sky130_fd_sc_hd__dfxtp_1
X_4173_ _2086_ vssd1 vssd1 vccd1 vccd1 _0545_ sky130_fd_sc_hd__clkbuf_1
X_3124_ _1549_ _1495_ _1550_ vssd1 vssd1 vccd1 vccd1 _1551_ sky130_fd_sc_hd__and3b_1
X_3055_ u_timer.count_reg\[6\] u_timer.count_reg\[5\] u_timer.count_reg\[4\] _1494_
+ vssd1 vssd1 vccd1 vccd1 _1502_ sky130_fd_sc_hd__and4_1
Xclkbuf_leaf_47_clk clknet_2_0__leaf_clk vssd1 vssd1 vccd1 vccd1 clknet_leaf_47_clk
+ sky130_fd_sc_hd__clkbuf_16
XFILLER_0_26_93 vssd1 vssd1 vccd1 vccd1 sky130_fd_sc_hd__fill_1
X_3957_ _1974_ vssd1 vssd1 vccd1 vccd1 _0441_ sky130_fd_sc_hd__clkbuf_1
X_2908_ _1073_ _1102_ net17 _1365_ vssd1 vssd1 vccd1 vccd1 _1366_ sky130_fd_sc_hd__a31oi_4
XFILLER_0_45_232 vssd1 vssd1 vccd1 vccd1 sky130_fd_sc_hd__decap_4
X_3888_ net404 vssd1 vssd1 vccd1 vccd1 _1940_ sky130_fd_sc_hd__clkbuf_1
XFILLER_0_45_298 vssd1 vssd1 vccd1 vccd1 sky130_fd_sc_hd__decap_3
X_2839_ _0845_ _1296_ vssd1 vssd1 vccd1 vccd1 _1297_ sky130_fd_sc_hd__or2_2
XFILLER_0_41_482 vssd1 vssd1 vccd1 vccd1 sky130_fd_sc_hd__decap_6
X_4509_ clknet_leaf_27_clk _0310_ vssd1 vssd1 vccd1 vccd1 u_core.u_regfile.rf\[2\]\[7\]
+ sky130_fd_sc_hd__dfxtp_1
Xwire1 _1473_ vssd1 vssd1 vccd1 vccd1 net564 sky130_fd_sc_hd__buf_1
XFILLER_0_6_81 vssd1 vssd1 vccd1 vccd1 sky130_fd_sc_hd__decap_3
XTAP_390 vssd1 vccd1 sky130_fd_sc_hd__tapvpwrvgnd_1
Xclkbuf_leaf_38_clk clknet_2_1__leaf_clk vssd1 vssd1 vccd1 vccd1 clknet_leaf_38_clk
+ sky130_fd_sc_hd__clkbuf_16
XFILLER_0_68_313 vssd1 vssd1 vccd1 vccd1 sky130_fd_sc_hd__decap_8
XPHY_30 vssd1 vssd1 vccd1 vccd1 sky130_fd_sc_hd__decap_3
XFILLER_0_68_357 vssd1 vssd1 vccd1 vccd1 sky130_fd_sc_hd__decap_6
XPHY_41 vssd1 vssd1 vccd1 vccd1 sky130_fd_sc_hd__decap_3
XPHY_52 vssd1 vssd1 vccd1 vccd1 sky130_fd_sc_hd__decap_3
XPHY_63 vssd1 vssd1 vccd1 vccd1 sky130_fd_sc_hd__decap_3
XPHY_74 vssd1 vssd1 vccd1 vccd1 sky130_fd_sc_hd__decap_3
XFILLER_0_56_508 vssd1 vssd1 vccd1 vccd1 sky130_fd_sc_hd__fill_2
XFILLER_0_83_349 vccd1 vssd1 vccd1 vssd1 sky130_ef_sc_hd__decap_12
XFILLER_0_22_29 vssd1 vssd1 vccd1 vccd1 sky130_fd_sc_hd__decap_3
XPHY_85 vssd1 vssd1 vccd1 vccd1 sky130_fd_sc_hd__decap_3
XPHY_96 vssd1 vssd1 vccd1 vccd1 sky130_fd_sc_hd__decap_3
XFILLER_0_36_243 vssd1 vssd1 vccd1 vccd1 sky130_fd_sc_hd__decap_8
XFILLER_0_24_405 vssd1 vssd1 vccd1 vccd1 sky130_fd_sc_hd__fill_1
XFILLER_0_51_246 vssd1 vssd1 vccd1 vccd1 sky130_fd_sc_hd__decap_4
XFILLER_0_47_15 vccd1 vssd1 vccd1 vssd1 sky130_ef_sc_hd__decap_12
Xclkbuf_leaf_29_clk clknet_2_1__leaf_clk vssd1 vssd1 vccd1 vccd1 clknet_leaf_29_clk
+ sky130_fd_sc_hd__clkbuf_16
XFILLER_0_59_335 vssd1 vssd1 vccd1 vccd1 sky130_fd_sc_hd__fill_1
X_3811_ _1901_ vssd1 vssd1 vccd1 vccd1 _0368_ sky130_fd_sc_hd__clkbuf_1
X_4791_ clknet_leaf_35_clk _0559_ vssd1 vssd1 vccd1 vccd1 u_core.u_regfile.rf\[3\]\[24\]
+ sky130_fd_sc_hd__dfxtp_1
X_3742_ _1861_ _1428_ _1864_ vssd1 vssd1 vccd1 vccd1 _0336_ sky130_fd_sc_hd__o21ai_1
X_3673_ net288 vssd1 vssd1 vccd1 vccd1 _1829_ sky130_fd_sc_hd__clkbuf_1
XFILLER_0_42_235 vccd1 vssd1 vccd1 vssd1 sky130_ef_sc_hd__decap_12
X_2624_ _1080_ _1081_ _0750_ vssd1 vssd1 vccd1 vccd1 _1082_ sky130_fd_sc_hd__nand3_2
XFILLER_0_2_321 vccd1 vssd1 vccd1 vssd1 sky130_ef_sc_hd__decap_12
XFILLER_0_2_365 vccd1 vssd1 vccd1 vssd1 sky130_ef_sc_hd__decap_12
XFILLER_0_23_471 vssd1 vssd1 vccd1 vccd1 sky130_fd_sc_hd__decap_4
X_2555_ _0744_ _0747_ _0749_ u_core.u_regfile.rf\[4\]\[3\] vssd1 vssd1 vccd1 vccd1
+ _1013_ sky130_fd_sc_hd__o22a_1
X_2486_ _0813_ _0941_ _0942_ _0943_ vssd1 vssd1 vccd1 vccd1 _0944_ sky130_fd_sc_hd__a31o_4
X_4225_ _1564_ _1481_ _2112_ vssd1 vssd1 vccd1 vccd1 _0571_ sky130_fd_sc_hd__a21oi_1
X_4156_ net274 vssd1 vssd1 vccd1 vccd1 _2078_ sky130_fd_sc_hd__clkbuf_1
X_3107_ _1539_ vssd1 vssd1 vccd1 vccd1 _0019_ sky130_fd_sc_hd__clkbuf_1
Xmax_cap19 _0739_ vssd1 vssd1 vccd1 vccd1 net19 sky130_fd_sc_hd__buf_4
X_4087_ _2039_ vssd1 vssd1 vccd1 vccd1 _0506_ sky130_fd_sc_hd__clkbuf_1
X_3038_ _0684_ vssd1 vssd1 vccd1 vccd1 _1490_ sky130_fd_sc_hd__buf_2
XFILLER_0_73_393 vssd1 vssd1 vccd1 vccd1 sky130_fd_sc_hd__decap_6
XFILLER_0_33_246 vssd1 vssd1 vccd1 vccd1 sky130_fd_sc_hd__decap_3
XFILLER_0_33_279 vssd1 vssd1 vccd1 vccd1 sky130_fd_sc_hd__fill_1
XFILLER_0_68_165 vssd1 vssd1 vccd1 vccd1 sky130_fd_sc_hd__fill_1
XFILLER_0_83_113 vssd1 vssd1 vccd1 vccd1 sky130_fd_sc_hd__fill_2
XFILLER_0_56_338 vssd1 vssd1 vccd1 vccd1 sky130_fd_sc_hd__decap_4
XFILLER_0_68_187 vssd1 vssd1 vccd1 vccd1 sky130_fd_sc_hd__decap_4
XFILLER_0_49_390 vssd1 vssd1 vccd1 vccd1 sky130_fd_sc_hd__fill_2
XFILLER_0_3_129 vssd1 vssd1 vccd1 vccd1 sky130_fd_sc_hd__fill_1
XFILLER_0_24_246 vssd1 vssd1 vccd1 vccd1 sky130_fd_sc_hd__decap_6
X_2340_ u_core.u_regfile.rf\[1\]\[27\] _0743_ _0759_ _0711_ vssd1 vssd1 vccd1 vccd1
+ _0798_ sky130_fd_sc_hd__o2bb2a_1
XFILLER_0_58_58 vccd1 vssd1 vccd1 vssd1 sky130_ef_sc_hd__decap_12
X_2271_ _0688_ vssd1 vssd1 vccd1 vccd1 _0729_ sky130_fd_sc_hd__inv_2
X_4010_ net217 vssd1 vssd1 vccd1 vccd1 _2001_ sky130_fd_sc_hd__clkbuf_1
XFILLER_0_7_402 vccd1 vssd1 vccd1 vssd1 sky130_ef_sc_hd__decap_12
X_4774_ clknet_leaf_31_clk _0542_ vssd1 vssd1 vccd1 vccd1 u_core.u_regfile.rf\[3\]\[7\]
+ sky130_fd_sc_hd__dfxtp_1
X_3725_ net236 vssd1 vssd1 vccd1 vccd1 _1855_ sky130_fd_sc_hd__clkbuf_1
Xclkbuf_leaf_9_clk clknet_2_2__leaf_clk vssd1 vssd1 vccd1 vccd1 clknet_leaf_9_clk
+ sky130_fd_sc_hd__clkbuf_16
XFILLER_0_70_363 vssd1 vssd1 vccd1 vccd1 sky130_fd_sc_hd__fill_1
X_3656_ _1820_ vssd1 vssd1 vccd1 vccd1 _0294_ sky130_fd_sc_hd__clkbuf_1
X_3587_ _1791_ _1792_ _1793_ net55 vssd1 vssd1 vccd1 vccd1 _0252_ sky130_fd_sc_hd__o31a_1
XFILLER_0_30_249 vssd1 vssd1 vccd1 vccd1 sky130_fd_sc_hd__decap_3
X_2607_ _1061_ _0900_ _0723_ vssd1 vssd1 vccd1 vccd1 _1065_ sky130_fd_sc_hd__o21ai_1
XFILLER_0_61_3 vccd1 vssd1 vccd1 vssd1 sky130_ef_sc_hd__decap_12
X_2538_ _0993_ _0994_ _0995_ vssd1 vssd1 vccd1 vccd1 _0996_ sky130_fd_sc_hd__a21oi_4
X_4208_ net220 vssd1 vssd1 vccd1 vccd1 _2104_ sky130_fd_sc_hd__clkbuf_1
X_2469_ _0925_ _0926_ vssd1 vssd1 vccd1 vccd1 _0927_ sky130_fd_sc_hd__and2_1
XFILLER_0_3_60 vssd1 vssd1 vccd1 vccd1 sky130_fd_sc_hd__fill_1
X_4139_ net5 _2062_ _2068_ _2061_ vssd1 vssd1 vccd1 vccd1 _0529_ sky130_fd_sc_hd__o2bb2ai_1
XFILLER_0_78_485 vccd1 vssd1 vccd1 vssd1 sky130_ef_sc_hd__decap_12
XFILLER_0_38_305 vssd1 vssd1 vccd1 vccd1 sky130_fd_sc_hd__decap_3
XFILLER_0_61_352 vssd1 vssd1 vccd1 vccd1 sky130_fd_sc_hd__fill_2
XFILLER_0_44_27 vssd1 vssd1 vccd1 vccd1 sky130_fd_sc_hd__fill_1
XFILLER_0_69_452 vccd1 vssd1 vccd1 vssd1 sky130_ef_sc_hd__decap_12
XFILLER_0_84_433 vccd1 vssd1 vccd1 vssd1 sky130_ef_sc_hd__decap_12
XFILLER_0_29_349 vssd1 vssd1 vccd1 vccd1 sky130_fd_sc_hd__fill_1
XFILLER_0_60_15 vccd1 vssd1 vccd1 vssd1 sky130_ef_sc_hd__decap_12
XFILLER_0_84_477 vccd1 vssd1 vccd1 vssd1 sky130_ef_sc_hd__decap_12
XFILLER_0_25_500 vssd1 vssd1 vccd1 vccd1 sky130_fd_sc_hd__decap_4
XFILLER_0_37_393 vssd1 vssd1 vccd1 vccd1 sky130_fd_sc_hd__fill_2
XFILLER_0_8_27 vssd1 vssd1 vccd1 vccd1 sky130_fd_sc_hd__fill_1
X_3510_ net423 vssd1 vssd1 vccd1 vccd1 _1760_ sky130_fd_sc_hd__clkbuf_1
XFILLER_0_52_363 vssd1 vssd1 vccd1 vccd1 sky130_fd_sc_hd__fill_1
XFILLER_0_64_190 vssd1 vssd1 vccd1 vccd1 sky130_fd_sc_hd__decap_3
X_4490_ clknet_leaf_22_clk _0291_ vssd1 vssd1 vccd1 vccd1 u_core.u_regfile.rf\[30\]\[20\]
+ sky130_fd_sc_hd__dfxtp_1
XFILLER_0_69_35 vssd1 vssd1 vccd1 vccd1 sky130_fd_sc_hd__fill_1
X_3441_ _1703_ _1704_ _1716_ vssd1 vssd1 vccd1 vccd1 _0183_ sky130_fd_sc_hd__o21ai_1
XTAP_901 vssd1 vccd1 sky130_fd_sc_hd__tapvpwrvgnd_1
X_3372_ _1668_ _1669_ _1670_ net112 vssd1 vssd1 vccd1 vccd1 _0160_ sky130_fd_sc_hd__o31a_1
XTAP_934 vssd1 vccd1 sky130_fd_sc_hd__tapvpwrvgnd_1
XTAP_923 vssd1 vccd1 sky130_fd_sc_hd__tapvpwrvgnd_1
XTAP_912 vssd1 vccd1 sky130_fd_sc_hd__tapvpwrvgnd_1
XFILLER_0_20_271 vssd1 vssd1 vccd1 vccd1 sky130_fd_sc_hd__fill_1
XFILLER_0_20_282 vssd1 vssd1 vccd1 vccd1 sky130_fd_sc_hd__decap_3
XFILLER_0_20_293 vssd1 vssd1 vccd1 vccd1 sky130_fd_sc_hd__fill_2
X_2323_ _0780_ vssd1 vssd1 vccd1 vccd1 _0781_ sky130_fd_sc_hd__clkbuf_4
XTAP_956 vssd1 vccd1 sky130_fd_sc_hd__tapvpwrvgnd_1
XTAP_945 vssd1 vccd1 sky130_fd_sc_hd__tapvpwrvgnd_1
X_2254_ _0711_ vssd1 vssd1 vccd1 vccd1 _0712_ sky130_fd_sc_hd__buf_2
X_2185_ u_timer.count_reg\[1\] _0641_ _0643_ u_timer.count_reg\[0\] vssd1 vssd1 vccd1
+ vccd1 _0644_ sky130_fd_sc_hd__o22ai_1
XFILLER_0_79_249 vssd1 vssd1 vccd1 vccd1 sky130_fd_sc_hd__decap_8
XFILLER_0_62_127 vssd1 vssd1 vccd1 vccd1 sky130_fd_sc_hd__fill_2
XFILLER_0_62_138 vssd1 vssd1 vccd1 vccd1 sky130_fd_sc_hd__fill_2
X_4757_ clknet_leaf_15_clk net469 net29 vssd1 vssd1 vccd1 vccd1 u_timer.count_reg\[23\]
+ sky130_fd_sc_hd__dfrtp_2
X_3708_ _1846_ vssd1 vssd1 vccd1 vccd1 _0320_ sky130_fd_sc_hd__clkbuf_1
X_4688_ clknet_leaf_38_clk _0489_ vssd1 vssd1 vccd1 vccd1 u_core.u_regfile.rf\[24\]\[26\]
+ sky130_fd_sc_hd__dfxtp_1
X_3639_ net194 vssd1 vssd1 vccd1 vccd1 _1812_ sky130_fd_sc_hd__clkbuf_1
XFILLER_0_11_260 vssd1 vssd1 vccd1 vccd1 sky130_fd_sc_hd__decap_4
XFILLER_0_85_219 vssd1 vssd1 vccd1 vccd1 sky130_fd_sc_hd__decap_4
XFILLER_0_81_447 vssd1 vssd1 vccd1 vccd1 sky130_fd_sc_hd__fill_1
XFILLER_0_19_393 vssd1 vssd1 vccd1 vccd1 sky130_fd_sc_hd__decap_8
XFILLER_0_34_352 vssd1 vssd1 vccd1 vccd1 sky130_fd_sc_hd__fill_1
XTAP_208 vssd1 vccd1 sky130_fd_sc_hd__tapvpwrvgnd_1
XTAP_219 vssd1 vccd1 sky130_fd_sc_hd__tapvpwrvgnd_1
Xhold4 u_core.u_regfile.rf\[28\]\[0\] vssd1 vssd1 vccd1 vccd1 net37 sky130_fd_sc_hd__dlygate4sd3_1
XFILLER_0_55_15 vccd1 vssd1 vccd1 vssd1 sky130_ef_sc_hd__decap_12
X_3990_ net277 vssd1 vssd1 vccd1 vccd1 _1991_ sky130_fd_sc_hd__clkbuf_1
XFILLER_0_71_69 vccd1 vssd1 vccd1 vssd1 sky130_ef_sc_hd__decap_12
XFILLER_0_29_124 vssd1 vssd1 vccd1 vccd1 sky130_fd_sc_hd__decap_8
X_2941_ _1206_ _1207_ vssd1 vssd1 vccd1 vccd1 _1399_ sky130_fd_sc_hd__or2_1
X_4611_ clknet_leaf_41_clk _0412_ vssd1 vssd1 vccd1 vccd1 u_core.u_regfile.rf\[1\]\[13\]
+ sky130_fd_sc_hd__dfxtp_1
X_2872_ _1328_ _1329_ vssd1 vssd1 vccd1 vccd1 _1330_ sky130_fd_sc_hd__nand2_1
X_4542_ clknet_leaf_43_clk _0343_ vssd1 vssd1 vccd1 vccd1 u_core.u_regfile.rf\[28\]\[8\]
+ sky130_fd_sc_hd__dfxtp_1
Xhold415 u_core.u_regfile.rf\[28\]\[10\] vssd1 vssd1 vccd1 vccd1 net448 sky130_fd_sc_hd__dlygate4sd3_1
Xhold404 u_core.u_regfile.rf\[4\]\[25\] vssd1 vssd1 vccd1 vccd1 net437 sky130_fd_sc_hd__dlygate4sd3_1
X_4473_ clknet_leaf_22_clk _0274_ vssd1 vssd1 vccd1 vccd1 u_core.u_regfile.rf\[30\]\[3\]
+ sky130_fd_sc_hd__dfxtp_1
Xhold426 u_timer.threshold_reg\[0\] vssd1 vssd1 vccd1 vccd1 net459 sky130_fd_sc_hd__dlygate4sd3_1
X_3424_ _0635_ _1680_ _1701_ vssd1 vssd1 vccd1 vccd1 _0181_ sky130_fd_sc_hd__a21oi_1
Xhold437 u_core.u_regfile.rf\[4\]\[5\] vssd1 vssd1 vccd1 vccd1 net470 sky130_fd_sc_hd__dlygate4sd3_1
Xhold448 u_core.u_regfile.rf\[4\]\[15\] vssd1 vssd1 vccd1 vccd1 net481 sky130_fd_sc_hd__dlygate4sd3_1
Xhold459 u_core.u_regfile.rf\[5\]\[12\] vssd1 vssd1 vccd1 vccd1 net492 sky130_fd_sc_hd__dlygate4sd3_1
XFILLER_0_40_377 vssd1 vssd1 vccd1 vccd1 sky130_fd_sc_hd__fill_1
X_3355_ _1482_ _1666_ _1667_ net53 vssd1 vssd1 vccd1 vccd1 _0146_ sky130_fd_sc_hd__o31a_1
XTAP_720 vssd1 vccd1 sky130_fd_sc_hd__tapvpwrvgnd_1
XTAP_731 vssd1 vccd1 sky130_fd_sc_hd__tapvpwrvgnd_1
XTAP_742 vssd1 vccd1 sky130_fd_sc_hd__tapvpwrvgnd_1
X_3286_ net418 vssd1 vssd1 vccd1 vccd1 _1634_ sky130_fd_sc_hd__clkbuf_1
X_2306_ _0716_ u_core.u_regfile.rf\[7\]\[29\] _0754_ _0756_ _0763_ vssd1 vssd1 vccd1
+ vccd1 _0764_ sky130_fd_sc_hd__a311o_1
XTAP_753 vssd1 vccd1 sky130_fd_sc_hd__tapvpwrvgnd_1
XTAP_764 vssd1 vccd1 sky130_fd_sc_hd__tapvpwrvgnd_1
XTAP_775 vssd1 vccd1 sky130_fd_sc_hd__tapvpwrvgnd_1
XTAP_786 vssd1 vccd1 sky130_fd_sc_hd__tapvpwrvgnd_1
X_2237_ u_imem.addr\[3\] vssd1 vssd1 vccd1 vccd1 _0695_ sky130_fd_sc_hd__buf_4
XTAP_797 vssd1 vccd1 sky130_fd_sc_hd__tapvpwrvgnd_1
XFILLER_0_24_3 vccd1 vssd1 vccd1 vssd1 sky130_ef_sc_hd__decap_12
X_2168_ net543 vssd1 vssd1 vccd1 vccd1 _0627_ sky130_fd_sc_hd__inv_2
XFILLER_0_48_477 vccd1 vssd1 vccd1 vssd1 sky130_ef_sc_hd__decap_12
XFILLER_0_31_388 vssd1 vssd1 vccd1 vccd1 sky130_fd_sc_hd__decap_4
XFILLER_0_1_249 vccd1 vssd1 vccd1 vssd1 sky130_ef_sc_hd__decap_12
X_3140_ net466 _1559_ _1490_ vssd1 vssd1 vccd1 vccd1 _0031_ sky130_fd_sc_hd__o21a_1
X_3071_ _1490_ _1512_ _1513_ vssd1 vssd1 vccd1 vccd1 _1514_ sky130_fd_sc_hd__and3_1
X_3973_ _1982_ vssd1 vssd1 vccd1 vccd1 _0449_ sky130_fd_sc_hd__clkbuf_1
X_2924_ _1344_ _1381_ vssd1 vssd1 vccd1 vccd1 _1382_ sky130_fd_sc_hd__nand2_1
XFILLER_0_45_447 vssd1 vssd1 vccd1 vccd1 sky130_fd_sc_hd__fill_1
XFILLER_0_45_469 vssd1 vssd1 vccd1 vccd1 sky130_fd_sc_hd__fill_2
X_2855_ _1308_ _0736_ _1312_ vssd1 vssd1 vccd1 vccd1 _1313_ sky130_fd_sc_hd__and3b_1
XFILLER_0_13_300 vssd1 vssd1 vccd1 vccd1 sky130_fd_sc_hd__decap_8
XFILLER_0_60_439 vssd1 vssd1 vccd1 vccd1 sky130_fd_sc_hd__fill_2
Xhold201 u_core.u_regfile.rf\[24\]\[0\] vssd1 vssd1 vccd1 vccd1 net234 sky130_fd_sc_hd__dlygate4sd3_1
X_2786_ _0913_ u_core.u_regfile.rf\[1\]\[23\] _0858_ _0914_ vssd1 vssd1 vccd1 vccd1
+ _1244_ sky130_fd_sc_hd__a31o_1
X_4525_ clknet_leaf_25_clk _0326_ vssd1 vssd1 vccd1 vccd1 u_core.u_regfile.rf\[2\]\[23\]
+ sky130_fd_sc_hd__dfxtp_1
Xhold223 u_core.u_regfile.rf\[24\]\[26\] vssd1 vssd1 vccd1 vccd1 net256 sky130_fd_sc_hd__dlygate4sd3_1
Xhold234 u_core.u_regfile.rf\[24\]\[15\] vssd1 vssd1 vccd1 vccd1 net267 sky130_fd_sc_hd__dlygate4sd3_1
Xhold212 u_core.u_regfile.rf\[30\]\[28\] vssd1 vssd1 vccd1 vccd1 net245 sky130_fd_sc_hd__dlygate4sd3_1
Xhold267 u_core.u_regfile.rf\[2\]\[12\] vssd1 vssd1 vccd1 vccd1 net300 sky130_fd_sc_hd__dlygate4sd3_1
Xhold278 u_core.u_regfile.rf\[25\]\[30\] vssd1 vssd1 vccd1 vccd1 net311 sky130_fd_sc_hd__dlygate4sd3_1
Xhold256 u_core.u_regfile.rf\[30\]\[31\] vssd1 vssd1 vccd1 vccd1 net289 sky130_fd_sc_hd__dlygate4sd3_1
Xhold245 u_core.u_regfile.rf\[26\]\[17\] vssd1 vssd1 vccd1 vccd1 net278 sky130_fd_sc_hd__dlygate4sd3_1
X_4456_ clknet_leaf_1_clk _0257_ vssd1 vssd1 vccd1 vccd1 u_core.u_regfile.rf\[7\]\[18\]
+ sky130_fd_sc_hd__dfxtp_1
X_4387_ clknet_leaf_15_clk _0198_ net28 vssd1 vssd1 vccd1 vccd1 u_timer.threshold_reg\[23\]
+ sky130_fd_sc_hd__dfrtp_1
Xhold289 u_core.u_regfile.rf\[30\]\[26\] vssd1 vssd1 vccd1 vccd1 net322 sky130_fd_sc_hd__dlygate4sd3_1
X_3407_ _1688_ _1689_ _1678_ _1683_ _1686_ vssd1 vssd1 vccd1 vccd1 _1690_ sky130_fd_sc_hd__o2111a_1
XFILLER_0_0_293 vccd1 vssd1 vccd1 vssd1 sky130_ef_sc_hd__decap_12
X_3338_ net488 vssd1 vssd1 vccd1 vccd1 _1660_ sky130_fd_sc_hd__clkbuf_1
XTAP_550 vssd1 vccd1 sky130_fd_sc_hd__tapvpwrvgnd_1
XTAP_561 vssd1 vccd1 sky130_fd_sc_hd__tapvpwrvgnd_1
XTAP_572 vssd1 vccd1 sky130_fd_sc_hd__tapvpwrvgnd_1
XTAP_583 vssd1 vccd1 sky130_fd_sc_hd__tapvpwrvgnd_1
XTAP_594 vssd1 vccd1 sky130_fd_sc_hd__tapvpwrvgnd_1
X_3269_ _1487_ vssd1 vssd1 vccd1 vccd1 _1629_ sky130_fd_sc_hd__buf_2
XFILLER_0_83_509 vssd1 vssd1 vccd1 vccd1 sky130_fd_sc_hd__fill_1
XFILLER_0_8_393 vssd1 vssd1 vccd1 vccd1 sky130_fd_sc_hd__fill_2
XFILLER_0_16_182 vssd1 vssd1 vccd1 vccd1 sky130_fd_sc_hd__decap_3
XFILLER_0_52_27 vssd1 vssd1 vccd1 vccd1 sky130_fd_sc_hd__fill_1
XFILLER_0_39_285 vssd1 vssd1 vccd1 vccd1 sky130_fd_sc_hd__fill_1
XFILLER_0_27_447 vssd1 vssd1 vccd1 vccd1 sky130_fd_sc_hd__fill_1
X_2640_ _1096_ _0697_ _0733_ _0904_ _1097_ vssd1 vssd1 vccd1 vccd1 _1098_ sky130_fd_sc_hd__o221ai_1
X_2571_ _0721_ u_core.u_regfile.rf\[31\]\[0\] vssd1 vssd1 vccd1 vccd1 _1029_ sky130_fd_sc_hd__nand2_1
X_4310_ clknet_leaf_46_clk _0121_ vssd1 vssd1 vccd1 vccd1 u_core.u_regfile.rf\[4\]\[10\]
+ sky130_fd_sc_hd__dfxtp_1
XFILLER_0_77_57 vccd1 vssd1 vccd1 vssd1 sky130_ef_sc_hd__decap_12
XFILLER_0_10_347 vssd1 vssd1 vccd1 vccd1 sky130_fd_sc_hd__fill_1
X_4241_ clknet_leaf_45_clk _0056_ vssd1 vssd1 vccd1 vccd1 u_core.u_regfile.rf\[31\]\[9\]
+ sky130_fd_sc_hd__dfxtp_1
X_4172_ net283 vssd1 vssd1 vccd1 vccd1 _2086_ sky130_fd_sc_hd__clkbuf_1
X_3123_ u_timer.count_reg\[25\] u_timer.count_reg\[24\] _1544_ u_timer.count_reg\[26\]
+ vssd1 vssd1 vccd1 vccd1 _1550_ sky130_fd_sc_hd__a31o_1
X_3054_ net446 _1498_ _1501_ vssd1 vssd1 vccd1 vccd1 _0034_ sky130_fd_sc_hd__a21oi_1
XFILLER_0_26_72 vssd1 vssd1 vccd1 vccd1 sky130_fd_sc_hd__decap_4
XFILLER_0_77_325 vssd1 vssd1 vccd1 vccd1 sky130_fd_sc_hd__decap_8
XFILLER_0_65_509 vssd1 vssd1 vccd1 vccd1 sky130_fd_sc_hd__fill_1
X_3956_ net150 vssd1 vssd1 vccd1 vccd1 _1974_ sky130_fd_sc_hd__clkbuf_1
XFILLER_0_45_200 vssd1 vssd1 vccd1 vccd1 sky130_fd_sc_hd__decap_3
X_2907_ _1127_ _1141_ vssd1 vssd1 vccd1 vccd1 _1365_ sky130_fd_sc_hd__nand2_1
X_3887_ _1939_ vssd1 vssd1 vccd1 vccd1 _0406_ sky130_fd_sc_hd__clkbuf_1
XFILLER_0_60_214 vssd1 vssd1 vccd1 vccd1 sky130_fd_sc_hd__decap_3
X_2838_ _0781_ _0839_ _0844_ vssd1 vssd1 vccd1 vccd1 _1296_ sky130_fd_sc_hd__o21ba_1
X_2769_ _0808_ _0762_ u_core.u_regfile.rf\[6\]\[21\] vssd1 vssd1 vccd1 vccd1 _1227_
+ sky130_fd_sc_hd__o21ai_1
X_4508_ clknet_leaf_22_clk _0309_ vssd1 vssd1 vccd1 vccd1 u_core.u_regfile.rf\[2\]\[6\]
+ sky130_fd_sc_hd__dfxtp_1
X_4439_ clknet_leaf_50_clk _0240_ vssd1 vssd1 vccd1 vccd1 u_core.u_regfile.rf\[7\]\[1\]
+ sky130_fd_sc_hd__dfxtp_1
XTAP_380 vssd1 vccd1 sky130_fd_sc_hd__tapvpwrvgnd_1
XTAP_391 vssd1 vccd1 sky130_fd_sc_hd__tapvpwrvgnd_1
XPHY_31 vssd1 vssd1 vccd1 vccd1 sky130_fd_sc_hd__decap_3
XPHY_20 vssd1 vssd1 vccd1 vccd1 sky130_fd_sc_hd__decap_3
XPHY_42 vssd1 vssd1 vccd1 vccd1 sky130_fd_sc_hd__decap_3
XPHY_53 vssd1 vssd1 vccd1 vccd1 sky130_fd_sc_hd__decap_3
XPHY_64 vssd1 vssd1 vccd1 vccd1 sky130_fd_sc_hd__decap_3
XFILLER_0_68_369 vssd1 vssd1 vccd1 vccd1 sky130_fd_sc_hd__fill_1
XPHY_75 vssd1 vssd1 vccd1 vccd1 sky130_fd_sc_hd__decap_3
XPHY_86 vssd1 vssd1 vccd1 vccd1 sky130_fd_sc_hd__decap_3
XPHY_97 vssd1 vssd1 vccd1 vccd1 sky130_fd_sc_hd__decap_3
XFILLER_0_51_225 vssd1 vssd1 vccd1 vccd1 sky130_fd_sc_hd__decap_4
XFILLER_0_47_27 vccd1 vssd1 vccd1 vssd1 sky130_ef_sc_hd__decap_12
XFILLER_0_2_29 vccd1 vssd1 vccd1 vssd1 sky130_ef_sc_hd__decap_12
XFILLER_0_47_509 vssd1 vssd1 vccd1 vccd1 sky130_fd_sc_hd__fill_1
X_3810_ net261 vssd1 vssd1 vccd1 vccd1 _1901_ sky130_fd_sc_hd__clkbuf_1
X_4790_ clknet_leaf_25_clk _0558_ vssd1 vssd1 vccd1 vccd1 u_core.u_regfile.rf\[3\]\[23\]
+ sky130_fd_sc_hd__dfxtp_1
XFILLER_0_6_105 vssd1 vssd1 vccd1 vccd1 sky130_fd_sc_hd__fill_1
X_3741_ _1674_ _1862_ net74 vssd1 vssd1 vccd1 vccd1 _1864_ sky130_fd_sc_hd__o21ai_1
XFILLER_0_82_361 vssd1 vssd1 vccd1 vccd1 sky130_fd_sc_hd__decap_3
XFILLER_0_70_501 vssd1 vssd1 vccd1 vccd1 sky130_fd_sc_hd__decap_8
X_3672_ _1828_ vssd1 vssd1 vccd1 vccd1 _0302_ sky130_fd_sc_hd__clkbuf_1
X_2623_ _0731_ _0761_ u_core.u_regfile.rf\[6\]\[5\] vssd1 vssd1 vccd1 vccd1 _1081_
+ sky130_fd_sc_hd__o21ai_1
XFILLER_0_42_247 vssd1 vssd1 vccd1 vccd1 sky130_fd_sc_hd__decap_4
X_2554_ _1010_ _0938_ _0939_ _1011_ _0881_ vssd1 vssd1 vccd1 vccd1 _1012_ sky130_fd_sc_hd__o2111ai_4
XFILLER_0_2_333 vccd1 vssd1 vccd1 vssd1 sky130_ef_sc_hd__decap_12
XFILLER_0_2_377 vccd1 vssd1 vccd1 vssd1 sky130_ef_sc_hd__decap_12
X_2485_ _0866_ u_core.u_regfile.rf\[1\]\[9\] _0857_ _0867_ vssd1 vssd1 vccd1 vccd1
+ _0943_ sky130_fd_sc_hd__a31o_1
X_4224_ _1093_ _1693_ net12 _1694_ _1695_ vssd1 vssd1 vccd1 vccd1 _2112_ sky130_fd_sc_hd__o2111a_1
X_4155_ _2077_ vssd1 vssd1 vccd1 vccd1 _0536_ sky130_fd_sc_hd__clkbuf_1
X_3106_ _1490_ _1537_ _1538_ vssd1 vssd1 vccd1 vccd1 _1539_ sky130_fd_sc_hd__and3_1
X_4086_ net154 vssd1 vssd1 vccd1 vccd1 _2039_ sky130_fd_sc_hd__clkbuf_1
X_3037_ net513 _0001_ vssd1 vssd1 vccd1 vccd1 _0007_ sky130_fd_sc_hd__nor2_1
XFILLER_0_38_509 vssd1 vssd1 vccd1 vccd1 sky130_fd_sc_hd__fill_1
XFILLER_0_80_309 vssd1 vssd1 vccd1 vccd1 sky130_fd_sc_hd__fill_2
X_3939_ _1965_ vssd1 vssd1 vccd1 vccd1 _0432_ sky130_fd_sc_hd__clkbuf_1
XFILLER_0_18_266 vssd1 vssd1 vccd1 vccd1 sky130_fd_sc_hd__fill_1
XFILLER_0_29_509 vssd1 vssd1 vccd1 vccd1 sky130_fd_sc_hd__fill_1
XFILLER_0_83_169 vccd1 vssd1 vccd1 vssd1 sky130_ef_sc_hd__decap_12
XFILLER_0_3_108 vssd1 vssd1 vccd1 vccd1 sky130_fd_sc_hd__decap_4
XFILLER_0_58_15 vccd1 vssd1 vccd1 vssd1 sky130_ef_sc_hd__decap_12
X_2270_ _0727_ vssd1 vssd1 vccd1 vccd1 _0728_ sky130_fd_sc_hd__clkbuf_8
XFILLER_0_59_177 vccd1 vssd1 vccd1 vssd1 sky130_ef_sc_hd__decap_12
XFILLER_0_7_414 vssd1 vssd1 vccd1 vccd1 sky130_fd_sc_hd__decap_8
X_4773_ clknet_leaf_38_clk _0541_ vssd1 vssd1 vccd1 vccd1 u_core.u_regfile.rf\[3\]\[6\]
+ sky130_fd_sc_hd__dfxtp_1
XFILLER_0_55_350 vssd1 vssd1 vccd1 vccd1 sky130_fd_sc_hd__decap_3
XFILLER_0_15_236 vssd1 vssd1 vccd1 vccd1 sky130_fd_sc_hd__decap_4
X_3724_ _1854_ vssd1 vssd1 vccd1 vccd1 _0328_ sky130_fd_sc_hd__clkbuf_1
X_3655_ net285 vssd1 vssd1 vccd1 vccd1 _1820_ sky130_fd_sc_hd__clkbuf_1
X_2606_ u_core.u_regfile.rf\[5\]\[2\] _0693_ vssd1 vssd1 vccd1 vccd1 _1064_ sky130_fd_sc_hd__nor2_1
XFILLER_0_11_442 vssd1 vssd1 vccd1 vccd1 sky130_fd_sc_hd__decap_3
X_3586_ _1791_ _1792_ _1793_ net93 vssd1 vssd1 vccd1 vccd1 _0251_ sky130_fd_sc_hd__o31a_1
X_2537_ u_core.u_regfile.rf\[31\]\[11\] _0726_ _0858_ _0758_ vssd1 vssd1 vccd1 vccd1
+ _0995_ sky130_fd_sc_hd__a2bb2o_1
XFILLER_0_11_486 vssd1 vssd1 vccd1 vccd1 sky130_fd_sc_hd__fill_2
X_2468_ u_core.u_regfile.rf\[1\]\[15\] _0742_ _0808_ _0710_ vssd1 vssd1 vccd1 vccd1
+ _0926_ sky130_fd_sc_hd__o2bb2a_1
XFILLER_0_54_3 vccd1 vssd1 vccd1 vssd1 sky130_ef_sc_hd__decap_12
X_4207_ _2103_ vssd1 vssd1 vccd1 vccd1 _0562_ sky130_fd_sc_hd__clkbuf_1
X_2399_ _0811_ vssd1 vssd1 vccd1 vccd1 _0857_ sky130_fd_sc_hd__clkbuf_4
X_4138_ _1737_ _1715_ _1706_ _2067_ vssd1 vssd1 vccd1 vccd1 _2068_ sky130_fd_sc_hd__nand4_1
X_4069_ _2030_ vssd1 vssd1 vccd1 vccd1 _0497_ sky130_fd_sc_hd__clkbuf_1
XFILLER_0_78_453 vssd1 vssd1 vccd1 vccd1 sky130_fd_sc_hd__decap_3
XFILLER_0_78_497 vccd1 vssd1 vccd1 vssd1 sky130_ef_sc_hd__decap_12
XFILLER_0_78_475 vssd1 vssd1 vccd1 vccd1 sky130_fd_sc_hd__fill_1
XFILLER_0_65_103 vssd1 vssd1 vccd1 vccd1 sky130_fd_sc_hd__fill_1
XFILLER_0_65_169 vssd1 vssd1 vccd1 vccd1 sky130_fd_sc_hd__fill_2
XFILLER_0_61_386 vssd1 vssd1 vccd1 vccd1 sky130_fd_sc_hd__decap_3
XFILLER_0_21_239 vssd1 vssd1 vccd1 vccd1 sky130_fd_sc_hd__decap_8
XFILLER_0_84_401 vccd1 vssd1 vccd1 vssd1 sky130_ef_sc_hd__decap_12
XFILLER_0_69_464 vssd1 vssd1 vccd1 vccd1 sky130_fd_sc_hd__fill_2
XFILLER_0_84_445 vccd1 vssd1 vccd1 vssd1 sky130_ef_sc_hd__decap_12
XFILLER_0_60_27 vssd1 vssd1 vccd1 vccd1 sky130_fd_sc_hd__fill_1
XFILLER_0_84_489 vccd1 vssd1 vccd1 vssd1 sky130_ef_sc_hd__decap_12
X_3440_ _1705_ _1706_ _1714_ _1715_ _0627_ vssd1 vssd1 vccd1 vccd1 _1716_ sky130_fd_sc_hd__a41o_1
X_3371_ _1668_ _1669_ _1670_ net71 vssd1 vssd1 vccd1 vccd1 _0159_ sky130_fd_sc_hd__o31a_1
XTAP_935 vssd1 vccd1 sky130_fd_sc_hd__tapvpwrvgnd_1
XTAP_924 vssd1 vccd1 sky130_fd_sc_hd__tapvpwrvgnd_1
XTAP_913 vssd1 vccd1 sky130_fd_sc_hd__tapvpwrvgnd_1
XTAP_902 vssd1 vccd1 sky130_fd_sc_hd__tapvpwrvgnd_1
X_2322_ _0779_ vssd1 vssd1 vccd1 vccd1 _0780_ sky130_fd_sc_hd__clkbuf_4
XTAP_957 vssd1 vccd1 sky130_fd_sc_hd__tapvpwrvgnd_1
XFILLER_0_85_57 vccd1 vssd1 vccd1 vssd1 sky130_ef_sc_hd__decap_12
XTAP_946 vssd1 vccd1 sky130_fd_sc_hd__tapvpwrvgnd_1
X_2253_ _0710_ vssd1 vssd1 vccd1 vccd1 _0711_ sky130_fd_sc_hd__buf_4
X_2184_ net459 vssd1 vssd1 vccd1 vccd1 _0643_ sky130_fd_sc_hd__inv_2
XFILLER_0_47_147 vssd1 vssd1 vccd1 vccd1 sky130_fd_sc_hd__fill_1
XFILLER_0_7_200 vssd1 vssd1 vccd1 vccd1 sky130_fd_sc_hd__decap_8
XFILLER_0_47_169 vssd1 vssd1 vccd1 vccd1 sky130_fd_sc_hd__decap_4
XFILLER_0_28_361 vssd1 vssd1 vccd1 vccd1 sky130_fd_sc_hd__decap_3
X_4756_ clknet_leaf_15_clk _0021_ net28 vssd1 vssd1 vccd1 vccd1 u_timer.count_reg\[22\]
+ sky130_fd_sc_hd__dfrtp_4
X_4687_ clknet_leaf_23_clk _0488_ vssd1 vssd1 vccd1 vccd1 u_core.u_regfile.rf\[24\]\[25\]
+ sky130_fd_sc_hd__dfxtp_1
X_3707_ net326 vssd1 vssd1 vccd1 vccd1 _1846_ sky130_fd_sc_hd__clkbuf_1
XFILLER_0_43_375 vssd1 vssd1 vccd1 vccd1 sky130_fd_sc_hd__decap_3
XFILLER_0_3_461 vccd1 vssd1 vccd1 vssd1 sky130_ef_sc_hd__decap_12
X_3638_ _1811_ vssd1 vssd1 vccd1 vccd1 _0285_ sky130_fd_sc_hd__clkbuf_1
XFILLER_0_70_194 vssd1 vssd1 vccd1 vccd1 sky130_fd_sc_hd__fill_2
X_3569_ _1789_ vssd1 vssd1 vccd1 vccd1 _0238_ sky130_fd_sc_hd__clkbuf_1
XFILLER_0_85_209 vssd1 vssd1 vccd1 vccd1 sky130_fd_sc_hd__decap_3
XFILLER_0_78_261 vccd1 vssd1 vccd1 vssd1 sky130_ef_sc_hd__decap_12
XFILLER_0_53_128 vssd1 vssd1 vccd1 vccd1 sky130_fd_sc_hd__decap_8
XTAP_209 vssd1 vccd1 sky130_fd_sc_hd__tapvpwrvgnd_1
Xhold5 u_core.u_regfile.rf\[5\]\[0\] vssd1 vssd1 vccd1 vccd1 net38 sky130_fd_sc_hd__dlygate4sd3_1
XFILLER_0_55_27 vccd1 vssd1 vccd1 vssd1 sky130_ef_sc_hd__decap_12
XFILLER_0_71_15 vccd1 vssd1 vccd1 vssd1 sky130_ef_sc_hd__decap_12
XFILLER_0_9_509 vssd1 vssd1 vccd1 vccd1 sky130_fd_sc_hd__fill_1
X_2940_ _1393_ _1394_ _1396_ _1397_ vssd1 vssd1 vccd1 vccd1 _1398_ sky130_fd_sc_hd__a22oi_1
XFILLER_0_84_264 vssd1 vssd1 vccd1 vccd1 sky130_fd_sc_hd__decap_3
X_2871_ _1308_ _0782_ _1312_ vssd1 vssd1 vccd1 vccd1 _1329_ sky130_fd_sc_hd__or3b_1
X_4610_ clknet_leaf_40_clk _0411_ vssd1 vssd1 vccd1 vccd1 u_core.u_regfile.rf\[1\]\[12\]
+ sky130_fd_sc_hd__dfxtp_1
XFILLER_0_44_139 vssd1 vssd1 vccd1 vccd1 sky130_fd_sc_hd__fill_1
XFILLER_0_20_41 vssd1 vssd1 vccd1 vccd1 sky130_fd_sc_hd__fill_1
X_4541_ clknet_leaf_43_clk _0342_ vssd1 vssd1 vccd1 vccd1 u_core.u_regfile.rf\[28\]\[7\]
+ sky130_fd_sc_hd__dfxtp_1
Xhold427 u_core.u_regfile.rf\[4\]\[13\] vssd1 vssd1 vccd1 vccd1 net460 sky130_fd_sc_hd__dlygate4sd3_1
X_4472_ clknet_leaf_47_clk _0273_ vssd1 vssd1 vccd1 vccd1 u_core.u_regfile.rf\[30\]\[2\]
+ sky130_fd_sc_hd__dfxtp_1
XFILLER_0_20_85 vssd1 vssd1 vccd1 vccd1 sky130_fd_sc_hd__decap_8
Xhold405 u_core.u_regfile.rf\[29\]\[13\] vssd1 vssd1 vccd1 vccd1 net438 sky130_fd_sc_hd__dlygate4sd3_1
Xhold416 u_core.u_regfile.rf\[29\]\[0\] vssd1 vssd1 vccd1 vccd1 net449 sky130_fd_sc_hd__dlygate4sd3_1
Xhold449 u_core.u_regfile.rf\[31\]\[14\] vssd1 vssd1 vccd1 vccd1 net482 sky130_fd_sc_hd__dlygate4sd3_1
Xhold438 u_audio.sample_reg\[3\] vssd1 vssd1 vccd1 vccd1 net471 sky130_fd_sc_hd__dlygate4sd3_1
X_3423_ _1700_ _1112_ _1678_ _1694_ _1695_ vssd1 vssd1 vccd1 vccd1 _1701_ sky130_fd_sc_hd__o2111a_1
XTAP_710 vssd1 vccd1 sky130_fd_sc_hd__tapvpwrvgnd_1
X_3354_ _1482_ _1666_ _1667_ net131 vssd1 vssd1 vccd1 vccd1 _0145_ sky130_fd_sc_hd__o31a_1
XTAP_721 vssd1 vccd1 sky130_fd_sc_hd__tapvpwrvgnd_1
XTAP_732 vssd1 vccd1 sky130_fd_sc_hd__tapvpwrvgnd_1
XTAP_743 vssd1 vccd1 sky130_fd_sc_hd__tapvpwrvgnd_1
X_3285_ _1632_ _1633_ _1483_ net143 vssd1 vssd1 vccd1 vccd1 _0110_ sky130_fd_sc_hd__o31a_1
X_2305_ _0759_ _0762_ u_core.u_regfile.rf\[6\]\[29\] vssd1 vssd1 vccd1 vccd1 _0763_
+ sky130_fd_sc_hd__o21a_1
XTAP_754 vssd1 vccd1 sky130_fd_sc_hd__tapvpwrvgnd_1
XTAP_765 vssd1 vccd1 sky130_fd_sc_hd__tapvpwrvgnd_1
XTAP_776 vssd1 vccd1 sky130_fd_sc_hd__tapvpwrvgnd_1
X_2236_ _0693_ vssd1 vssd1 vccd1 vccd1 _0694_ sky130_fd_sc_hd__buf_4
XTAP_787 vssd1 vccd1 sky130_fd_sc_hd__tapvpwrvgnd_1
XTAP_798 vssd1 vccd1 sky130_fd_sc_hd__tapvpwrvgnd_1
X_2167_ _0625_ u_timer.count_reg\[12\] _0617_ u_timer.count_reg\[13\] vssd1 vssd1
+ vccd1 vccd1 _0626_ sky130_fd_sc_hd__a22o_1
XFILLER_0_17_3 vccd1 vssd1 vccd1 vssd1 sky130_ef_sc_hd__decap_12
XFILLER_0_48_489 vssd1 vssd1 vccd1 vccd1 sky130_fd_sc_hd__decap_4
XFILLER_0_16_331 vccd1 vssd1 vccd1 vssd1 sky130_ef_sc_hd__decap_12
X_4739_ clknet_leaf_14_clk _0034_ net25 vssd1 vssd1 vccd1 vccd1 u_timer.count_reg\[5\]
+ sky130_fd_sc_hd__dfrtp_2
XFILLER_0_58_209 vssd1 vssd1 vccd1 vccd1 sky130_fd_sc_hd__decap_8
XFILLER_0_39_467 vssd1 vssd1 vccd1 vccd1 sky130_fd_sc_hd__fill_1
XFILLER_0_66_253 vssd1 vssd1 vccd1 vccd1 sky130_fd_sc_hd__fill_1
XFILLER_0_22_323 vssd1 vssd1 vccd1 vccd1 sky130_fd_sc_hd__fill_1
XFILLER_0_22_345 vssd1 vssd1 vccd1 vccd1 sky130_fd_sc_hd__fill_1
XFILLER_0_66_15 vccd1 vssd1 vccd1 vssd1 sky130_ef_sc_hd__decap_12
X_3070_ u_timer.count_reg\[10\] _1509_ vssd1 vssd1 vccd1 vccd1 _1513_ sky130_fd_sc_hd__nand2_1
XFILLER_0_15_52 vssd1 vssd1 vccd1 vccd1 sky130_fd_sc_hd__decap_4
X_3972_ net353 vssd1 vssd1 vccd1 vccd1 _1982_ sky130_fd_sc_hd__clkbuf_1
X_2923_ _1268_ _1270_ _1342_ _1368_ _1380_ vssd1 vssd1 vccd1 vccd1 _1381_ sky130_fd_sc_hd__o221ai_4
X_2854_ _0772_ _0774_ _0694_ u_core.u_regfile.rf\[5\]\[30\] _1311_ vssd1 vssd1 vccd1
+ vccd1 _1312_ sky130_fd_sc_hd__o221a_1
X_2785_ _0744_ _0748_ _0885_ u_core.u_regfile.rf\[4\]\[23\] vssd1 vssd1 vccd1 vccd1
+ _1243_ sky130_fd_sc_hd__o22a_1
XFILLER_0_53_470 vssd1 vssd1 vccd1 vccd1 sky130_fd_sc_hd__fill_1
X_4524_ clknet_leaf_35_clk _0325_ vssd1 vssd1 vccd1 vccd1 u_core.u_regfile.rf\[2\]\[22\]
+ sky130_fd_sc_hd__dfxtp_1
Xhold202 u_core.u_regfile.rf\[3\]\[3\] vssd1 vssd1 vccd1 vccd1 net235 sky130_fd_sc_hd__dlygate4sd3_1
Xhold235 u_core.u_regfile.rf\[24\]\[17\] vssd1 vssd1 vccd1 vccd1 net268 sky130_fd_sc_hd__dlygate4sd3_1
Xhold213 u_core.u_regfile.rf\[2\]\[27\] vssd1 vssd1 vccd1 vccd1 net246 sky130_fd_sc_hd__dlygate4sd3_1
Xhold224 u_core.u_regfile.rf\[27\]\[3\] vssd1 vssd1 vccd1 vccd1 net257 sky130_fd_sc_hd__dlygate4sd3_1
X_4455_ clknet_leaf_0_clk _0256_ vssd1 vssd1 vccd1 vccd1 u_core.u_regfile.rf\[7\]\[17\]
+ sky130_fd_sc_hd__dfxtp_1
Xhold257 u_core.u_regfile.rf\[26\]\[15\] vssd1 vssd1 vccd1 vccd1 net290 sky130_fd_sc_hd__dlygate4sd3_1
Xhold246 u_core.u_regfile.rf\[24\]\[22\] vssd1 vssd1 vccd1 vccd1 net279 sky130_fd_sc_hd__dlygate4sd3_1
Xhold268 u_core.u_regfile.rf\[30\]\[7\] vssd1 vssd1 vccd1 vccd1 net301 sky130_fd_sc_hd__dlygate4sd3_1
X_4386_ clknet_leaf_15_clk _0197_ net28 vssd1 vssd1 vccd1 vccd1 u_timer.threshold_reg\[22\]
+ sky130_fd_sc_hd__dfrtp_1
Xhold279 u_core.u_regfile.rf\[2\]\[2\] vssd1 vssd1 vccd1 vccd1 net312 sky130_fd_sc_hd__dlygate4sd3_1
X_3406_ _1041_ vssd1 vssd1 vccd1 vccd1 _1689_ sky130_fd_sc_hd__inv_2
X_3337_ _1659_ vssd1 vssd1 vccd1 vccd1 _0136_ sky130_fd_sc_hd__clkbuf_1
XTAP_540 vssd1 vccd1 sky130_fd_sc_hd__tapvpwrvgnd_1
XTAP_551 vssd1 vccd1 sky130_fd_sc_hd__tapvpwrvgnd_1
XTAP_562 vssd1 vccd1 sky130_fd_sc_hd__tapvpwrvgnd_1
XTAP_573 vssd1 vccd1 sky130_fd_sc_hd__tapvpwrvgnd_1
XTAP_584 vssd1 vccd1 sky130_fd_sc_hd__tapvpwrvgnd_1
X_3268_ _1626_ _1627_ _1628_ net336 vssd1 vssd1 vccd1 vccd1 _0098_ sky130_fd_sc_hd__o31a_1
XTAP_595 vssd1 vccd1 sky130_fd_sc_hd__tapvpwrvgnd_1
X_2219_ u_timer.count_reg\[21\] _0673_ u_timer.count_reg\[20\] _0666_ _0677_ vssd1
+ vssd1 vccd1 vccd1 _0678_ sky130_fd_sc_hd__a221o_1
X_3199_ u_core.u_regfile.rf\[31\]\[10\] vssd1 vssd1 vccd1 vccd1 _1601_ sky130_fd_sc_hd__clkbuf_1
XFILLER_0_63_212 vssd1 vssd1 vccd1 vccd1 sky130_fd_sc_hd__fill_1
XFILLER_0_63_223 vssd1 vssd1 vccd1 vccd1 sky130_fd_sc_hd__fill_1
XFILLER_0_44_481 vssd1 vssd1 vccd1 vccd1 sky130_fd_sc_hd__fill_1
XFILLER_0_6_3 vccd1 vssd1 vccd1 vssd1 sky130_ef_sc_hd__decap_12
XFILLER_0_31_197 vssd1 vssd1 vccd1 vccd1 sky130_fd_sc_hd__fill_2
XFILLER_0_36_29 vssd1 vssd1 vccd1 vccd1 sky130_fd_sc_hd__decap_3
XFILLER_0_35_481 vssd1 vssd1 vccd1 vccd1 sky130_fd_sc_hd__decap_8
X_2570_ _1023_ _1026_ _1027_ vssd1 vssd1 vccd1 vccd1 _1028_ sky130_fd_sc_hd__o21ai_2
XFILLER_0_10_326 vssd1 vssd1 vccd1 vccd1 sky130_fd_sc_hd__decap_8
XFILLER_0_77_69 vccd1 vssd1 vccd1 vssd1 sky130_ef_sc_hd__decap_12
X_4240_ clknet_leaf_42_clk _0055_ vssd1 vssd1 vccd1 vccd1 u_core.u_regfile.rf\[31\]\[8\]
+ sky130_fd_sc_hd__dfxtp_1
X_4171_ _2085_ vssd1 vssd1 vccd1 vccd1 _0544_ sky130_fd_sc_hd__clkbuf_1
X_3122_ u_timer.count_reg\[26\] u_timer.count_reg\[25\] u_timer.count_reg\[24\] _1544_
+ vssd1 vssd1 vccd1 vccd1 _1549_ sky130_fd_sc_hd__and4_1
X_3053_ u_timer.count_reg\[5\] _1498_ _1490_ vssd1 vssd1 vccd1 vccd1 _1501_ sky130_fd_sc_hd__o21ai_1
X_3955_ _1973_ vssd1 vssd1 vccd1 vccd1 _0440_ sky130_fd_sc_hd__clkbuf_1
XFILLER_0_45_223 vssd1 vssd1 vccd1 vccd1 sky130_fd_sc_hd__fill_1
X_2906_ _1236_ _1237_ _1363_ _1275_ vssd1 vssd1 vccd1 vccd1 _1364_ sky130_fd_sc_hd__a22oi_2
X_3886_ net458 vssd1 vssd1 vccd1 vccd1 _1939_ sky130_fd_sc_hd__clkbuf_1
XFILLER_0_84_3 vccd1 vssd1 vccd1 vssd1 sky130_ef_sc_hd__decap_12
X_2837_ _0781_ _0820_ _0816_ vssd1 vssd1 vccd1 vccd1 _1295_ sky130_fd_sc_hd__nor3_2
X_2768_ _0840_ _0720_ _0740_ _0861_ u_core.u_regfile.rf\[7\]\[21\] vssd1 vssd1 vccd1
+ vccd1 _1226_ sky130_fd_sc_hd__o311a_1
X_2699_ _1154_ _1155_ _0751_ _1156_ vssd1 vssd1 vccd1 vccd1 _1157_ sky130_fd_sc_hd__a31oi_4
X_4507_ clknet_leaf_33_clk _0308_ vssd1 vssd1 vccd1 vccd1 u_core.u_regfile.rf\[2\]\[5\]
+ sky130_fd_sc_hd__dfxtp_1
X_4438_ clknet_leaf_0_clk _0239_ vssd1 vssd1 vccd1 vccd1 u_core.u_regfile.rf\[7\]\[0\]
+ sky130_fd_sc_hd__dfxtp_1
X_4369_ clknet_leaf_13_clk _0180_ net24 vssd1 vssd1 vccd1 vccd1 u_timer.threshold_reg\[5\]
+ sky130_fd_sc_hd__dfrtp_1
XTAP_370 vssd1 vccd1 sky130_fd_sc_hd__tapvpwrvgnd_1
XTAP_381 vssd1 vccd1 sky130_fd_sc_hd__tapvpwrvgnd_1
XTAP_392 vssd1 vccd1 sky130_fd_sc_hd__tapvpwrvgnd_1
XPHY_21 vssd1 vssd1 vccd1 vccd1 sky130_fd_sc_hd__decap_3
XPHY_10 vssd1 vssd1 vccd1 vccd1 sky130_fd_sc_hd__decap_3
XFILLER_0_83_307 vssd1 vssd1 vccd1 vccd1 sky130_fd_sc_hd__fill_1
XPHY_32 vssd1 vssd1 vccd1 vccd1 sky130_fd_sc_hd__decap_3
XPHY_43 vssd1 vssd1 vccd1 vccd1 sky130_fd_sc_hd__decap_3
XPHY_54 vssd1 vssd1 vccd1 vccd1 sky130_fd_sc_hd__decap_3
XPHY_65 vssd1 vssd1 vccd1 vccd1 sky130_fd_sc_hd__decap_3
XPHY_76 vssd1 vssd1 vccd1 vccd1 sky130_fd_sc_hd__decap_3
XPHY_87 vssd1 vssd1 vccd1 vccd1 sky130_fd_sc_hd__decap_3
XPHY_98 vssd1 vssd1 vccd1 vccd1 sky130_fd_sc_hd__decap_3
XFILLER_0_51_237 vssd1 vssd1 vccd1 vccd1 sky130_fd_sc_hd__fill_1
XFILLER_0_47_39 vssd1 vssd1 vccd1 vccd1 sky130_fd_sc_hd__decap_8
XFILLER_0_59_359 vccd1 vssd1 vccd1 vssd1 sky130_ef_sc_hd__decap_12
XFILLER_0_74_307 vssd1 vssd1 vccd1 vccd1 sky130_fd_sc_hd__fill_1
XFILLER_0_6_117 vssd1 vssd1 vccd1 vccd1 sky130_fd_sc_hd__fill_2
X_3740_ _1861_ _1430_ _1863_ vssd1 vssd1 vccd1 vccd1 _0335_ sky130_fd_sc_hd__o21ai_1
X_3671_ net289 vssd1 vssd1 vccd1 vccd1 _1828_ sky130_fd_sc_hd__clkbuf_1
XFILLER_0_27_289 vssd1 vssd1 vccd1 vccd1 sky130_fd_sc_hd__decap_8
X_2622_ _0938_ u_core.u_regfile.rf\[7\]\[5\] _0802_ vssd1 vssd1 vccd1 vccd1 _1080_
+ sky130_fd_sc_hd__nand3_1
XFILLER_0_2_301 vssd1 vssd1 vccd1 vccd1 sky130_fd_sc_hd__decap_6
X_2553_ _0860_ u_core.u_regfile.rf\[7\]\[3\] _0861_ vssd1 vssd1 vccd1 vccd1 _1011_
+ sky130_fd_sc_hd__nand3_1
XFILLER_0_2_345 vccd1 vssd1 vccd1 vssd1 sky130_ef_sc_hd__decap_12
XFILLER_0_2_389 vccd1 vssd1 vccd1 vssd1 sky130_ef_sc_hd__decap_12
X_2484_ _0700_ _0802_ u_core.u_regfile.rf\[4\]\[9\] vssd1 vssd1 vccd1 vccd1 _0942_
+ sky130_fd_sc_hd__a21o_1
X_4223_ _1565_ _1481_ _2111_ vssd1 vssd1 vccd1 vccd1 _0570_ sky130_fd_sc_hd__a21oi_1
X_4154_ net318 vssd1 vssd1 vccd1 vccd1 _2077_ sky130_fd_sc_hd__clkbuf_1
X_3105_ _0663_ _0674_ _0605_ _1532_ vssd1 vssd1 vccd1 vccd1 _1538_ sky130_fd_sc_hd__or4b_1
X_4085_ _2038_ vssd1 vssd1 vccd1 vccd1 _0505_ sky130_fd_sc_hd__clkbuf_1
XFILLER_0_37_72 vssd1 vssd1 vccd1 vccd1 sky130_fd_sc_hd__decap_4
X_3036_ _1488_ _1489_ net91 vssd1 vssd1 vccd1 vccd1 _0006_ sky130_fd_sc_hd__a21o_1
XFILLER_0_58_381 vssd1 vssd1 vccd1 vccd1 sky130_fd_sc_hd__fill_2
X_3938_ net323 vssd1 vssd1 vccd1 vccd1 _1965_ sky130_fd_sc_hd__clkbuf_1
XFILLER_0_73_384 vssd1 vssd1 vccd1 vccd1 sky130_fd_sc_hd__decap_3
X_3869_ _1930_ vssd1 vssd1 vccd1 vccd1 _0397_ sky130_fd_sc_hd__clkbuf_1
XFILLER_0_56_318 vccd1 vssd1 vccd1 vssd1 sky130_ef_sc_hd__decap_12
XFILLER_0_20_421 vssd1 vssd1 vccd1 vccd1 sky130_fd_sc_hd__fill_1
XFILLER_0_32_281 vssd1 vssd1 vccd1 vccd1 sky130_fd_sc_hd__fill_1
XFILLER_0_58_27 vssd1 vssd1 vccd1 vccd1 sky130_fd_sc_hd__fill_1
XFILLER_0_20_454 vssd1 vssd1 vccd1 vccd1 sky130_fd_sc_hd__fill_2
XFILLER_0_74_15 vccd1 vssd1 vccd1 vssd1 sky130_ef_sc_hd__decap_12
XFILLER_0_59_101 vssd1 vssd1 vccd1 vccd1 sky130_fd_sc_hd__decap_8
XFILLER_0_47_329 vssd1 vssd1 vccd1 vccd1 sky130_fd_sc_hd__fill_1
XFILLER_0_59_189 vssd1 vssd1 vccd1 vccd1 sky130_fd_sc_hd__decap_8
X_4772_ clknet_leaf_36_clk _0540_ vssd1 vssd1 vccd1 vccd1 u_core.u_regfile.rf\[3\]\[5\]
+ sky130_fd_sc_hd__dfxtp_1
XFILLER_0_7_426 vccd1 vssd1 vccd1 vssd1 sky130_ef_sc_hd__decap_12
X_3723_ net340 vssd1 vssd1 vccd1 vccd1 _1854_ sky130_fd_sc_hd__clkbuf_1
X_3654_ _1819_ vssd1 vssd1 vccd1 vccd1 _0293_ sky130_fd_sc_hd__clkbuf_1
XFILLER_0_70_332 vssd1 vssd1 vccd1 vccd1 sky130_fd_sc_hd__fill_1
X_2605_ _0900_ _1061_ _0734_ _1062_ vssd1 vssd1 vccd1 vccd1 _1063_ sky130_fd_sc_hd__o211ai_1
XFILLER_0_70_365 vssd1 vssd1 vccd1 vccd1 sky130_fd_sc_hd__decap_4
XFILLER_0_70_376 vssd1 vssd1 vccd1 vccd1 sky130_fd_sc_hd__decap_4
X_3585_ _1791_ _1792_ _1793_ net136 vssd1 vssd1 vccd1 vccd1 _0250_ sky130_fd_sc_hd__o31a_1
XFILLER_0_11_465 vssd1 vssd1 vccd1 vccd1 sky130_fd_sc_hd__fill_1
XFILLER_0_2_197 vccd1 vssd1 vccd1 vssd1 sky130_ef_sc_hd__decap_12
X_2536_ u_core.u_regfile.rf\[1\]\[11\] _0742_ _0758_ _0710_ vssd1 vssd1 vccd1 vccd1
+ _0994_ sky130_fd_sc_hd__o2bb2a_1
X_2467_ _0745_ _0748_ _0885_ u_core.u_regfile.rf\[4\]\[15\] _0924_ vssd1 vssd1 vccd1
+ vccd1 _0925_ sky130_fd_sc_hd__o221ai_4
XFILLER_0_47_3 vccd1 vssd1 vccd1 vssd1 sky130_ef_sc_hd__decap_12
X_4206_ net178 vssd1 vssd1 vccd1 vccd1 _2103_ sky130_fd_sc_hd__clkbuf_1
X_2398_ _0693_ u_core.u_regfile.rf\[5\]\[14\] _0723_ _0855_ vssd1 vssd1 vccd1 vccd1
+ _0856_ sky130_fd_sc_hd__o211ai_4
X_4137_ u_core.u_regfile.rf\[31\]\[2\] _1483_ _1052_ _1056_ net19 vssd1 vssd1 vccd1
+ vccd1 _2067_ sky130_fd_sc_hd__o221a_1
XFILLER_0_78_421 vccd1 vssd1 vccd1 vssd1 sky130_ef_sc_hd__decap_12
X_4068_ net280 vssd1 vssd1 vccd1 vccd1 _2030_ sky130_fd_sc_hd__clkbuf_1
X_3019_ _1313_ _1314_ _1476_ _1403_ vssd1 vssd1 vccd1 vccd1 _1477_ sky130_fd_sc_hd__o22ai_2
XFILLER_0_84_413 vssd1 vssd1 vccd1 vccd1 sky130_fd_sc_hd__decap_6
XFILLER_0_84_457 vccd1 vssd1 vccd1 vssd1 sky130_ef_sc_hd__decap_12
XFILLER_0_37_351 vssd1 vssd1 vccd1 vccd1 sky130_fd_sc_hd__decap_3
XFILLER_0_8_29 vccd1 vssd1 vccd1 vssd1 sky130_ef_sc_hd__decap_12
XFILLER_0_4_418 vssd1 vssd1 vccd1 vccd1 sky130_fd_sc_hd__fill_2
XFILLER_0_52_365 vccd1 vssd1 vccd1 vssd1 sky130_ef_sc_hd__decap_12
XFILLER_0_69_15 vccd1 vssd1 vccd1 vssd1 sky130_ef_sc_hd__decap_12
X_3370_ _1668_ _1669_ _1670_ net40 vssd1 vssd1 vccd1 vccd1 _0158_ sky130_fd_sc_hd__o31a_1
XTAP_925 vssd1 vccd1 sky130_fd_sc_hd__tapvpwrvgnd_1
XTAP_914 vssd1 vccd1 sky130_fd_sc_hd__tapvpwrvgnd_1
XTAP_903 vssd1 vccd1 sky130_fd_sc_hd__tapvpwrvgnd_1
X_2321_ _0776_ _0741_ _0752_ _0778_ vssd1 vssd1 vccd1 vccd1 _0779_ sky130_fd_sc_hd__o22a_4
XTAP_958 vssd1 vccd1 sky130_fd_sc_hd__tapvpwrvgnd_1
XTAP_947 vssd1 vccd1 sky130_fd_sc_hd__tapvpwrvgnd_1
XTAP_936 vssd1 vccd1 sky130_fd_sc_hd__tapvpwrvgnd_1
X_2252_ _0709_ vssd1 vssd1 vccd1 vccd1 _0710_ sky130_fd_sc_hd__clkbuf_4
XFILLER_0_85_69 vccd1 vssd1 vccd1 vssd1 sky130_ef_sc_hd__decap_12
X_2183_ _0641_ u_timer.count_reg\[1\] vssd1 vssd1 vccd1 vccd1 _0642_ sky130_fd_sc_hd__nand2_1
XFILLER_0_75_457 vssd1 vssd1 vccd1 vccd1 sky130_fd_sc_hd__fill_2
XFILLER_0_28_351 vssd1 vssd1 vccd1 vccd1 sky130_fd_sc_hd__fill_1
X_4755_ clknet_leaf_22_clk _0020_ net30 vssd1 vssd1 vccd1 vccd1 u_timer.count_reg\[21\]
+ sky130_fd_sc_hd__dfrtp_1
XFILLER_0_62_118 vssd1 vssd1 vccd1 vccd1 sky130_fd_sc_hd__fill_1
X_3706_ _1845_ vssd1 vssd1 vccd1 vccd1 _0319_ sky130_fd_sc_hd__clkbuf_1
XFILLER_0_50_83 vssd1 vssd1 vccd1 vccd1 sky130_fd_sc_hd__fill_1
XFILLER_0_55_192 vssd1 vssd1 vccd1 vccd1 sky130_fd_sc_hd__decap_3
X_4686_ clknet_leaf_36_clk _0487_ vssd1 vssd1 vccd1 vccd1 u_core.u_regfile.rf\[24\]\[24\]
+ sky130_fd_sc_hd__dfxtp_1
XFILLER_0_31_505 vssd1 vssd1 vccd1 vccd1 sky130_fd_sc_hd__decap_4
X_3637_ net237 vssd1 vssd1 vccd1 vccd1 _1811_ sky130_fd_sc_hd__clkbuf_1
XFILLER_0_3_473 vccd1 vssd1 vccd1 vssd1 sky130_ef_sc_hd__decap_12
X_3568_ net411 vssd1 vssd1 vccd1 vccd1 _1789_ sky130_fd_sc_hd__clkbuf_1
X_2519_ _0770_ _0975_ _0702_ _0881_ _0976_ vssd1 vssd1 vccd1 vccd1 _0977_ sky130_fd_sc_hd__a221o_1
X_3499_ u_timer.threshold_reg\[29\] vssd1 vssd1 vccd1 vccd1 _1754_ sky130_fd_sc_hd__inv_2
XFILLER_0_78_251 vssd1 vssd1 vccd1 vccd1 sky130_fd_sc_hd__fill_1
XFILLER_0_78_273 vccd1 vssd1 vccd1 vssd1 sky130_ef_sc_hd__decap_12
XFILLER_0_81_405 vccd1 vssd1 vccd1 vssd1 sky130_ef_sc_hd__decap_12
XFILLER_0_81_449 vccd1 vssd1 vccd1 vssd1 sky130_ef_sc_hd__decap_12
XFILLER_0_61_162 vssd1 vssd1 vccd1 vccd1 sky130_fd_sc_hd__decap_6
Xhold6 u_core.u_regfile.rf\[5\]\[1\] vssd1 vssd1 vccd1 vccd1 net39 sky130_fd_sc_hd__dlygate4sd3_1
XFILLER_0_55_39 vssd1 vssd1 vccd1 vccd1 sky130_fd_sc_hd__decap_8
XFILLER_0_71_27 vccd1 vssd1 vccd1 vssd1 sky130_ef_sc_hd__decap_12
X_2870_ _1326_ _1327_ vssd1 vssd1 vccd1 vccd1 _1328_ sky130_fd_sc_hd__or2_1
X_4540_ clknet_leaf_5_clk _0341_ vssd1 vssd1 vccd1 vccd1 u_core.u_regfile.rf\[28\]\[6\]
+ sky130_fd_sc_hd__dfxtp_1
Xclkbuf_leaf_10_clk clknet_2_2__leaf_clk vssd1 vssd1 vccd1 vccd1 clknet_leaf_10_clk
+ sky130_fd_sc_hd__clkbuf_16
X_4471_ clknet_leaf_35_clk _0272_ vssd1 vssd1 vccd1 vccd1 u_core.u_regfile.rf\[30\]\[1\]
+ sky130_fd_sc_hd__dfxtp_1
Xhold417 u_core.u_regfile.rf\[1\]\[6\] vssd1 vssd1 vccd1 vccd1 net450 sky130_fd_sc_hd__dlygate4sd3_1
Xhold406 u_core.u_regfile.rf\[4\]\[31\] vssd1 vssd1 vccd1 vccd1 net439 sky130_fd_sc_hd__dlygate4sd3_1
Xhold439 u_core.u_regfile.rf\[4\]\[10\] vssd1 vssd1 vccd1 vccd1 net472 sky130_fd_sc_hd__dlygate4sd3_1
XFILLER_0_0_421 vccd1 vssd1 vccd1 vssd1 sky130_ef_sc_hd__decap_12
X_3422_ u_core.u_regfile.rf\[31\]\[6\] _0728_ _1133_ _1304_ vssd1 vssd1 vccd1 vccd1
+ _1700_ sky130_fd_sc_hd__a2bb2o_1
Xhold428 u_core.u_regfile.rf\[28\]\[29\] vssd1 vssd1 vccd1 vccd1 net461 sky130_fd_sc_hd__dlygate4sd3_1
XTAP_700 vssd1 vccd1 sky130_fd_sc_hd__tapvpwrvgnd_1
X_3353_ _1482_ _1666_ _1667_ net39 vssd1 vssd1 vccd1 vccd1 _0144_ sky130_fd_sc_hd__o31a_1
XTAP_711 vssd1 vccd1 sky130_fd_sc_hd__tapvpwrvgnd_1
XTAP_722 vssd1 vccd1 sky130_fd_sc_hd__tapvpwrvgnd_1
XTAP_733 vssd1 vccd1 sky130_fd_sc_hd__tapvpwrvgnd_1
X_3284_ _1632_ _1633_ _1483_ net135 vssd1 vssd1 vccd1 vccd1 _0109_ sky130_fd_sc_hd__o31a_1
X_2304_ _0761_ vssd1 vssd1 vccd1 vccd1 _0762_ sky130_fd_sc_hd__clkbuf_4
XTAP_744 vssd1 vccd1 sky130_fd_sc_hd__tapvpwrvgnd_1
XTAP_755 vssd1 vccd1 sky130_fd_sc_hd__tapvpwrvgnd_1
XTAP_766 vssd1 vccd1 sky130_fd_sc_hd__tapvpwrvgnd_1
XTAP_777 vssd1 vccd1 sky130_fd_sc_hd__tapvpwrvgnd_1
X_2235_ _0692_ vssd1 vssd1 vccd1 vccd1 _0693_ sky130_fd_sc_hd__buf_4
XTAP_788 vssd1 vccd1 sky130_fd_sc_hd__tapvpwrvgnd_1
XTAP_799 vssd1 vccd1 sky130_fd_sc_hd__tapvpwrvgnd_1
X_2166_ net544 vssd1 vssd1 vccd1 vccd1 _0625_ sky130_fd_sc_hd__inv_2
XFILLER_0_0_41 vccd1 vssd1 vccd1 vssd1 sky130_ef_sc_hd__decap_12
XFILLER_0_48_424 vssd1 vssd1 vccd1 vccd1 sky130_fd_sc_hd__decap_8
XFILLER_0_48_435 vssd1 vssd1 vccd1 vccd1 sky130_fd_sc_hd__decap_4
XFILLER_0_0_85 vccd1 vssd1 vccd1 vssd1 sky130_ef_sc_hd__decap_12
XFILLER_0_16_343 vssd1 vssd1 vccd1 vccd1 sky130_fd_sc_hd__decap_4
X_2999_ _1454_ _1456_ vssd1 vssd1 vccd1 vccd1 _1457_ sky130_fd_sc_hd__nand2_1
XFILLER_0_63_449 vssd1 vssd1 vccd1 vccd1 sky130_fd_sc_hd__decap_4
X_4738_ clknet_leaf_13_clk _0033_ net25 vssd1 vssd1 vccd1 vccd1 u_timer.count_reg\[4\]
+ sky130_fd_sc_hd__dfrtp_2
XFILLER_0_71_482 vccd1 vssd1 vccd1 vssd1 sky130_ef_sc_hd__decap_12
X_4669_ clknet_leaf_22_clk _0470_ vssd1 vssd1 vccd1 vccd1 u_core.u_regfile.rf\[24\]\[7\]
+ sky130_fd_sc_hd__dfxtp_1
XFILLER_0_16_387 vssd1 vssd1 vccd1 vccd1 sky130_fd_sc_hd__fill_1
XFILLER_0_31_335 vssd1 vssd1 vccd1 vccd1 sky130_fd_sc_hd__fill_1
XFILLER_0_3_281 vccd1 vssd1 vccd1 vssd1 sky130_ef_sc_hd__decap_12
XFILLER_0_31_357 vssd1 vssd1 vccd1 vccd1 sky130_fd_sc_hd__decap_8
XFILLER_0_31_379 vssd1 vssd1 vccd1 vccd1 sky130_fd_sc_hd__fill_1
XFILLER_0_39_424 vssd1 vssd1 vccd1 vccd1 sky130_fd_sc_hd__fill_2
XFILLER_0_26_129 vssd1 vssd1 vccd1 vccd1 sky130_fd_sc_hd__decap_8
XFILLER_0_39_479 vccd1 vssd1 vccd1 vssd1 sky130_ef_sc_hd__decap_12
XFILLER_0_81_235 vssd1 vssd1 vccd1 vccd1 sky130_fd_sc_hd__decap_6
XFILLER_0_19_192 vssd1 vssd1 vccd1 vccd1 sky130_fd_sc_hd__fill_2
XFILLER_0_22_335 vssd1 vssd1 vccd1 vccd1 sky130_fd_sc_hd__fill_2
XFILLER_0_66_27 vssd1 vssd1 vccd1 vccd1 sky130_fd_sc_hd__fill_1
XFILLER_0_82_15 vccd1 vssd1 vccd1 vssd1 sky130_ef_sc_hd__decap_12
X_3971_ _1981_ vssd1 vssd1 vccd1 vccd1 _0448_ sky130_fd_sc_hd__clkbuf_1
X_2922_ _1339_ vssd1 vssd1 vccd1 vccd1 _1380_ sky130_fd_sc_hd__inv_2
XFILLER_0_17_129 vssd1 vssd1 vccd1 vccd1 sky130_fd_sc_hd__fill_1
X_2853_ u_core.u_regfile.rf\[28\]\[30\] _0698_ _0701_ _0703_ _1310_ vssd1 vssd1 vccd1
+ vccd1 _1311_ sky130_fd_sc_hd__a221o_1
X_2784_ _1240_ _0907_ _1241_ vssd1 vssd1 vccd1 vccd1 _1242_ sky130_fd_sc_hd__o21ai_2
XFILLER_0_60_408 vssd1 vssd1 vccd1 vccd1 sky130_fd_sc_hd__decap_4
X_4523_ clknet_leaf_50_clk _0324_ vssd1 vssd1 vccd1 vccd1 u_core.u_regfile.rf\[2\]\[21\]
+ sky130_fd_sc_hd__dfxtp_1
XFILLER_0_13_357 vssd1 vssd1 vccd1 vccd1 sky130_fd_sc_hd__decap_4
Xhold225 u_core.u_regfile.rf\[24\]\[13\] vssd1 vssd1 vccd1 vccd1 net258 sky130_fd_sc_hd__dlygate4sd3_1
Xhold214 u_core.u_regfile.rf\[3\]\[24\] vssd1 vssd1 vccd1 vccd1 net247 sky130_fd_sc_hd__dlygate4sd3_1
Xhold203 u_core.u_regfile.rf\[2\]\[26\] vssd1 vssd1 vccd1 vccd1 net236 sky130_fd_sc_hd__dlygate4sd3_1
X_4454_ clknet_leaf_0_clk _0255_ vssd1 vssd1 vccd1 vccd1 u_core.u_regfile.rf\[7\]\[16\]
+ sky130_fd_sc_hd__dfxtp_1
Xhold236 u_core.u_regfile.rf\[26\]\[13\] vssd1 vssd1 vccd1 vccd1 net269 sky130_fd_sc_hd__dlygate4sd3_1
Xhold247 u_core.u_regfile.rf\[25\]\[2\] vssd1 vssd1 vccd1 vccd1 net280 sky130_fd_sc_hd__dlygate4sd3_1
Xhold269 u_core.u_regfile.rf\[30\]\[17\] vssd1 vssd1 vccd1 vccd1 net302 sky130_fd_sc_hd__dlygate4sd3_1
Xhold258 u_core.u_regfile.rf\[30\]\[6\] vssd1 vssd1 vccd1 vccd1 net291 sky130_fd_sc_hd__dlygate4sd3_1
X_3405_ u_core.u_regfile.rf\[31\]\[1\] _1483_ _1133_ _1304_ vssd1 vssd1 vccd1 vccd1
+ _1688_ sky130_fd_sc_hd__a2bb2o_1
X_4385_ clknet_leaf_19_clk _0196_ net30 vssd1 vssd1 vccd1 vccd1 u_timer.threshold_reg\[21\]
+ sky130_fd_sc_hd__dfrtp_1
XTAP_530 vssd1 vccd1 sky130_fd_sc_hd__tapvpwrvgnd_1
XTAP_541 vssd1 vccd1 sky130_fd_sc_hd__tapvpwrvgnd_1
X_3336_ net437 vssd1 vssd1 vccd1 vccd1 _1659_ sky130_fd_sc_hd__clkbuf_1
XTAP_552 vssd1 vccd1 sky130_fd_sc_hd__tapvpwrvgnd_1
XTAP_563 vssd1 vccd1 sky130_fd_sc_hd__tapvpwrvgnd_1
XTAP_574 vssd1 vccd1 sky130_fd_sc_hd__tapvpwrvgnd_1
XTAP_585 vssd1 vccd1 sky130_fd_sc_hd__tapvpwrvgnd_1
X_3267_ _1626_ _1627_ _1628_ net132 vssd1 vssd1 vccd1 vccd1 _0097_ sky130_fd_sc_hd__o31a_1
XTAP_596 vssd1 vccd1 sky130_fd_sc_hd__tapvpwrvgnd_1
X_2218_ _0663_ u_timer.threshold_reg\[20\] _0676_ vssd1 vssd1 vccd1 vccd1 _0677_ sky130_fd_sc_hd__a21oi_1
X_3198_ _1600_ vssd1 vssd1 vccd1 vccd1 _0056_ sky130_fd_sc_hd__clkbuf_1
X_2149_ _0605_ u_timer.threshold_reg\[18\] _0606_ u_timer.threshold_reg\[17\] _0607_
+ vssd1 vssd1 vccd1 vccd1 _0608_ sky130_fd_sc_hd__a221o_1
XFILLER_0_68_508 vssd1 vssd1 vccd1 vccd1 sky130_fd_sc_hd__fill_2
XFILLER_0_63_202 vssd1 vssd1 vccd1 vccd1 sky130_fd_sc_hd__decap_4
XFILLER_0_44_471 vssd1 vssd1 vccd1 vccd1 sky130_fd_sc_hd__fill_2
XFILLER_0_52_29 vccd1 vssd1 vccd1 vssd1 sky130_ef_sc_hd__decap_12
XFILLER_0_54_213 vssd1 vssd1 vccd1 vccd1 sky130_fd_sc_hd__fill_1
XFILLER_0_42_419 vssd1 vssd1 vccd1 vccd1 sky130_fd_sc_hd__fill_1
XFILLER_0_54_268 vssd1 vssd1 vccd1 vccd1 sky130_fd_sc_hd__fill_1
XFILLER_0_35_493 vssd1 vssd1 vccd1 vccd1 sky130_fd_sc_hd__decap_8
XFILLER_0_77_15 vccd1 vssd1 vccd1 vssd1 sky130_ef_sc_hd__decap_12
X_4170_ net259 vssd1 vssd1 vccd1 vccd1 _2085_ sky130_fd_sc_hd__clkbuf_1
X_3121_ _1548_ vssd1 vssd1 vccd1 vccd1 _0024_ sky130_fd_sc_hd__clkbuf_1
X_3052_ _1500_ vssd1 vssd1 vccd1 vccd1 _0033_ sky130_fd_sc_hd__clkbuf_1
X_3954_ net156 vssd1 vssd1 vccd1 vccd1 _1973_ sky130_fd_sc_hd__clkbuf_1
XFILLER_0_85_393 vccd1 vssd1 vccd1 vssd1 sky130_ef_sc_hd__decap_12
X_3885_ _1938_ vssd1 vssd1 vccd1 vccd1 _0405_ sky130_fd_sc_hd__clkbuf_1
X_2905_ _1291_ _1341_ _1361_ _1362_ vssd1 vssd1 vccd1 vccd1 _1363_ sky130_fd_sc_hd__o2bb2ai_2
X_2836_ _0781_ _0816_ _0820_ vssd1 vssd1 vccd1 vccd1 _1294_ sky130_fd_sc_hd__o21a_2
X_2767_ u_core.u_regfile.rf\[31\]\[21\] _0895_ _0746_ _0715_ vssd1 vssd1 vccd1 vccd1
+ _1225_ sky130_fd_sc_hd__o22a_1
X_4506_ clknet_leaf_22_clk _0307_ vssd1 vssd1 vccd1 vccd1 u_core.u_regfile.rf\[2\]\[4\]
+ sky130_fd_sc_hd__dfxtp_1
XFILLER_0_77_3 vccd1 vssd1 vccd1 vssd1 sky130_ef_sc_hd__decap_12
X_2698_ u_core.u_regfile.rf\[4\]\[19\] _0885_ _0812_ vssd1 vssd1 vccd1 vccd1 _1156_
+ sky130_fd_sc_hd__o21ai_2
X_4437_ clknet_leaf_9_clk _0000_ net21 vssd1 vssd1 vccd1 vccd1 net2 sky130_fd_sc_hd__dfrtp_1
XFILLER_0_6_73 vssd1 vssd1 vccd1 vccd1 sky130_fd_sc_hd__decap_8
X_4368_ clknet_leaf_12_clk _0179_ net24 vssd1 vssd1 vccd1 vccd1 u_timer.threshold_reg\[4\]
+ sky130_fd_sc_hd__dfrtp_1
XTAP_360 vssd1 vccd1 sky130_fd_sc_hd__tapvpwrvgnd_1
X_3319_ _1650_ vssd1 vssd1 vccd1 vccd1 _0127_ sky130_fd_sc_hd__clkbuf_1
X_4299_ clknet_leaf_0_clk _0110_ vssd1 vssd1 vccd1 vccd1 u_core.u_regfile.rf\[6\]\[31\]
+ sky130_fd_sc_hd__dfxtp_1
XTAP_371 vssd1 vccd1 sky130_fd_sc_hd__tapvpwrvgnd_1
XTAP_382 vssd1 vccd1 sky130_fd_sc_hd__tapvpwrvgnd_1
XTAP_393 vssd1 vccd1 sky130_fd_sc_hd__tapvpwrvgnd_1
XPHY_22 vssd1 vssd1 vccd1 vccd1 sky130_fd_sc_hd__decap_3
XPHY_11 vssd1 vssd1 vccd1 vccd1 sky130_fd_sc_hd__decap_3
XPHY_33 vssd1 vssd1 vccd1 vccd1 sky130_fd_sc_hd__decap_3
XPHY_44 vssd1 vssd1 vccd1 vccd1 sky130_fd_sc_hd__decap_3
XPHY_55 vssd1 vssd1 vccd1 vccd1 sky130_fd_sc_hd__decap_3
XPHY_66 vssd1 vssd1 vccd1 vccd1 sky130_fd_sc_hd__decap_3
XPHY_77 vssd1 vssd1 vccd1 vccd1 sky130_fd_sc_hd__decap_3
XPHY_88 vssd1 vssd1 vccd1 vccd1 sky130_fd_sc_hd__decap_3
XFILLER_0_36_224 vssd1 vssd1 vccd1 vccd1 sky130_fd_sc_hd__decap_3
XPHY_99 vssd1 vssd1 vccd1 vccd1 sky130_fd_sc_hd__decap_3
XFILLER_0_32_485 vssd1 vssd1 vccd1 vccd1 sky130_fd_sc_hd__decap_6
XFILLER_0_67_393 vccd1 vssd1 vccd1 vssd1 sky130_ef_sc_hd__decap_12
XFILLER_0_82_341 vccd1 vssd1 vccd1 vssd1 sky130_ef_sc_hd__decap_12
XFILLER_0_42_205 vssd1 vssd1 vccd1 vccd1 sky130_fd_sc_hd__decap_4
X_3670_ _1827_ vssd1 vssd1 vccd1 vccd1 _0301_ sky130_fd_sc_hd__clkbuf_1
X_2621_ _0693_ u_core.u_regfile.rf\[5\]\[5\] _0723_ _1078_ vssd1 vssd1 vccd1 vccd1
+ _1079_ sky130_fd_sc_hd__o211a_1
X_2552_ u_core.u_regfile.rf\[6\]\[3\] vssd1 vssd1 vccd1 vccd1 _1010_ sky130_fd_sc_hd__inv_2
XFILLER_0_2_357 vssd1 vssd1 vccd1 vccd1 sky130_fd_sc_hd__decap_6
X_2483_ _0937_ _0938_ _0939_ _0940_ _0881_ vssd1 vssd1 vccd1 vccd1 _0941_ sky130_fd_sc_hd__o2111ai_4
X_4222_ _1009_ _1014_ net12 _1694_ _1695_ vssd1 vssd1 vccd1 vccd1 _2111_ sky130_fd_sc_hd__o2111a_1
X_4153_ _2076_ vssd1 vssd1 vccd1 vccd1 _0535_ sky130_fd_sc_hd__clkbuf_1
XFILLER_0_37_40 vssd1 vssd1 vccd1 vccd1 sky130_fd_sc_hd__decap_4
X_3104_ u_timer.count_reg\[19\] _1536_ u_timer.count_reg\[20\] vssd1 vssd1 vccd1 vccd1
+ _1537_ sky130_fd_sc_hd__a21o_1
X_4084_ net294 vssd1 vssd1 vccd1 vccd1 _2038_ sky130_fd_sc_hd__clkbuf_1
X_3035_ _0776_ _1304_ _0741_ _0752_ vssd1 vssd1 vccd1 vccd1 _1489_ sky130_fd_sc_hd__or4_1
XFILLER_0_53_50 vssd1 vssd1 vccd1 vccd1 sky130_fd_sc_hd__decap_6
XFILLER_0_46_500 vssd1 vssd1 vccd1 vccd1 sky130_fd_sc_hd__decap_8
XFILLER_0_58_360 vssd1 vssd1 vccd1 vccd1 sky130_fd_sc_hd__decap_4
X_3937_ _1964_ vssd1 vssd1 vccd1 vccd1 _0431_ sky130_fd_sc_hd__clkbuf_1
XFILLER_0_73_352 vccd1 vssd1 vccd1 vssd1 sky130_ef_sc_hd__decap_12
X_3868_ net161 vssd1 vssd1 vccd1 vccd1 _1930_ sky130_fd_sc_hd__clkbuf_1
XFILLER_0_33_216 vssd1 vssd1 vccd1 vccd1 sky130_fd_sc_hd__decap_8
XFILLER_0_5_151 vssd1 vssd1 vccd1 vccd1 sky130_fd_sc_hd__fill_1
X_2819_ _1260_ _1261_ _1269_ vssd1 vssd1 vccd1 vccd1 _1277_ sky130_fd_sc_hd__a21o_1
X_3799_ _1868_ _1337_ _1338_ _1895_ vssd1 vssd1 vccd1 vccd1 _0362_ sky130_fd_sc_hd__o31ai_1
XFILLER_0_14_485 vssd1 vssd1 vccd1 vccd1 sky130_fd_sc_hd__decap_6
XTAP_190 vssd1 vccd1 sky130_fd_sc_hd__tapvpwrvgnd_1
XFILLER_0_68_113 vssd1 vssd1 vccd1 vccd1 sky130_fd_sc_hd__decap_4
XFILLER_0_83_105 vssd1 vssd1 vccd1 vccd1 sky130_fd_sc_hd__decap_6
XFILLER_0_64_363 vssd1 vssd1 vccd1 vccd1 sky130_fd_sc_hd__fill_1
XFILLER_0_64_396 vssd1 vssd1 vccd1 vccd1 sky130_fd_sc_hd__fill_1
XFILLER_0_20_400 vssd1 vssd1 vccd1 vccd1 sky130_fd_sc_hd__fill_1
XFILLER_0_20_477 vssd1 vssd1 vccd1 vccd1 sky130_fd_sc_hd__fill_1
XFILLER_0_74_27 vssd1 vssd1 vccd1 vccd1 sky130_fd_sc_hd__fill_1
XFILLER_0_59_113 vssd1 vssd1 vccd1 vccd1 sky130_fd_sc_hd__decap_8
XFILLER_0_59_146 vssd1 vssd1 vccd1 vccd1 sky130_fd_sc_hd__fill_1
XFILLER_0_23_53 vssd1 vssd1 vccd1 vccd1 sky130_fd_sc_hd__decap_3
XFILLER_0_23_64 vssd1 vssd1 vccd1 vccd1 sky130_fd_sc_hd__decap_4
XFILLER_0_7_438 vssd1 vssd1 vccd1 vccd1 sky130_fd_sc_hd__fill_1
X_4771_ clknet_leaf_26_clk _0539_ vssd1 vssd1 vccd1 vccd1 u_core.u_regfile.rf\[3\]\[4\]
+ sky130_fd_sc_hd__dfxtp_1
XFILLER_0_55_341 vssd1 vssd1 vccd1 vccd1 sky130_fd_sc_hd__fill_1
XFILLER_0_67_190 vssd1 vssd1 vccd1 vccd1 sky130_fd_sc_hd__decap_4
X_3722_ _1853_ vssd1 vssd1 vccd1 vccd1 _0327_ sky130_fd_sc_hd__clkbuf_1
XFILLER_0_15_249 vssd1 vssd1 vccd1 vccd1 sky130_fd_sc_hd__fill_1
X_3653_ net350 vssd1 vssd1 vccd1 vccd1 _1819_ sky130_fd_sc_hd__clkbuf_1
X_2604_ u_core.u_regfile.rf\[5\]\[2\] _0733_ _0904_ _0769_ _0722_ vssd1 vssd1 vccd1
+ vccd1 _1062_ sky130_fd_sc_hd__o32a_1
X_3584_ _1791_ _1792_ _1793_ net82 vssd1 vssd1 vccd1 vccd1 _0249_ sky130_fd_sc_hd__o31a_1
X_2535_ _0744_ _0748_ _0885_ u_core.u_regfile.rf\[4\]\[11\] _0992_ vssd1 vssd1 vccd1
+ vccd1 _0993_ sky130_fd_sc_hd__o221ai_4
X_2466_ _0921_ _0923_ _0750_ vssd1 vssd1 vccd1 vccd1 _0924_ sky130_fd_sc_hd__nand3_2
X_4205_ _2102_ vssd1 vssd1 vccd1 vccd1 _0561_ sky130_fd_sc_hd__clkbuf_1
X_2397_ _0769_ _0853_ _0691_ _0700_ _0854_ vssd1 vssd1 vccd1 vccd1 _0855_ sky130_fd_sc_hd__a221o_1
X_4136_ net526 _2062_ _2066_ _2061_ vssd1 vssd1 vccd1 vccd1 _0528_ sky130_fd_sc_hd__o2bb2ai_1
X_4067_ _2029_ vssd1 vssd1 vccd1 vccd1 _0496_ sky130_fd_sc_hd__clkbuf_1
XFILLER_0_78_433 vccd1 vssd1 vccd1 vssd1 sky130_ef_sc_hd__decap_12
X_3018_ _1474_ _1475_ _0793_ vssd1 vssd1 vccd1 vccd1 _1476_ sky130_fd_sc_hd__a21boi_1
XFILLER_0_61_311 vssd1 vssd1 vccd1 vccd1 sky130_fd_sc_hd__fill_1
XFILLER_0_61_344 vssd1 vssd1 vccd1 vccd1 sky130_fd_sc_hd__decap_8
XFILLER_0_6_493 vssd1 vssd1 vccd1 vccd1 sky130_fd_sc_hd__fill_1
XFILLER_0_21_219 vssd1 vssd1 vccd1 vccd1 sky130_fd_sc_hd__fill_2
XFILLER_0_61_399 vssd1 vssd1 vccd1 vccd1 sky130_fd_sc_hd__fill_1
XFILLER_0_29_308 vssd1 vssd1 vccd1 vccd1 sky130_fd_sc_hd__fill_1
XFILLER_0_84_469 vssd1 vssd1 vccd1 vccd1 sky130_fd_sc_hd__decap_6
XFILLER_0_52_377 vssd1 vssd1 vccd1 vccd1 sky130_fd_sc_hd__fill_1
XFILLER_0_69_27 vssd1 vssd1 vccd1 vccd1 sky130_fd_sc_hd__decap_8
XFILLER_0_85_15 vccd1 vssd1 vccd1 vssd1 sky130_ef_sc_hd__decap_12
XTAP_926 vssd1 vccd1 sky130_fd_sc_hd__tapvpwrvgnd_1
XTAP_915 vssd1 vccd1 sky130_fd_sc_hd__tapvpwrvgnd_1
XTAP_904 vssd1 vccd1 sky130_fd_sc_hd__tapvpwrvgnd_1
X_2320_ _0777_ vssd1 vssd1 vccd1 vccd1 _0778_ sky130_fd_sc_hd__clkbuf_4
XTAP_959 vssd1 vccd1 sky130_fd_sc_hd__tapvpwrvgnd_1
XTAP_948 vssd1 vccd1 sky130_fd_sc_hd__tapvpwrvgnd_1
XFILLER_0_85_37 vssd1 vssd1 vccd1 vccd1 sky130_fd_sc_hd__fill_1
XTAP_937 vssd1 vccd1 sky130_fd_sc_hd__tapvpwrvgnd_1
X_2251_ _0695_ vssd1 vssd1 vccd1 vccd1 _0709_ sky130_fd_sc_hd__clkbuf_4
X_2182_ net489 vssd1 vssd1 vccd1 vccd1 _0641_ sky130_fd_sc_hd__inv_2
XFILLER_0_75_447 vssd1 vssd1 vccd1 vccd1 sky130_fd_sc_hd__fill_1
XFILLER_0_34_85 vssd1 vssd1 vccd1 vccd1 sky130_fd_sc_hd__decap_3
X_4754_ clknet_leaf_23_clk _0019_ net31 vssd1 vssd1 vccd1 vccd1 u_timer.count_reg\[20\]
+ sky130_fd_sc_hd__dfrtp_2
XFILLER_0_50_51 vssd1 vssd1 vccd1 vccd1 sky130_fd_sc_hd__fill_1
X_3705_ net157 vssd1 vssd1 vccd1 vccd1 _1845_ sky130_fd_sc_hd__clkbuf_1
XFILLER_0_28_396 vssd1 vssd1 vccd1 vccd1 sky130_fd_sc_hd__fill_1
X_4685_ clknet_leaf_34_clk _0486_ vssd1 vssd1 vccd1 vccd1 u_core.u_regfile.rf\[24\]\[23\]
+ sky130_fd_sc_hd__dfxtp_1
XFILLER_0_70_141 vccd1 vssd1 vccd1 vssd1 sky130_ef_sc_hd__decap_12
XFILLER_0_3_441 vssd1 vssd1 vccd1 vccd1 sky130_fd_sc_hd__decap_6
X_3636_ _1810_ vssd1 vssd1 vccd1 vccd1 _0284_ sky130_fd_sc_hd__clkbuf_1
XFILLER_0_70_185 vssd1 vssd1 vccd1 vccd1 sky130_fd_sc_hd__fill_1
XFILLER_0_3_485 vccd1 vssd1 vccd1 vssd1 sky130_ef_sc_hd__decap_12
X_3567_ _1788_ vssd1 vssd1 vccd1 vccd1 _0237_ sky130_fd_sc_hd__clkbuf_1
X_2518_ _0922_ _0740_ u_core.u_regfile.rf\[28\]\[10\] vssd1 vssd1 vccd1 vccd1 _0976_
+ sky130_fd_sc_hd__o21a_1
X_3498_ _0788_ _1741_ _1753_ vssd1 vssd1 vccd1 vccd1 _0203_ sky130_fd_sc_hd__o21ai_1
X_2449_ _0695_ _0737_ _0730_ vssd1 vssd1 vccd1 vccd1 _0907_ sky130_fd_sc_hd__a21oi_4
XFILLER_0_75_81 vccd1 vssd1 vccd1 vssd1 sky130_ef_sc_hd__decap_12
X_4119_ _2055_ vssd1 vssd1 vccd1 vccd1 _0522_ sky130_fd_sc_hd__clkbuf_1
XFILLER_0_78_285 vccd1 vssd1 vccd1 vssd1 sky130_ef_sc_hd__decap_12
XFILLER_0_38_127 vssd1 vssd1 vccd1 vccd1 sky130_fd_sc_hd__fill_1
XFILLER_0_38_149 vssd1 vssd1 vccd1 vccd1 sky130_fd_sc_hd__fill_2
XFILLER_0_66_458 vssd1 vssd1 vccd1 vccd1 sky130_fd_sc_hd__decap_3
XFILLER_0_81_417 vccd1 vssd1 vccd1 vssd1 sky130_ef_sc_hd__decap_12
Xhold7 u_core.u_regfile.rf\[5\]\[15\] vssd1 vssd1 vccd1 vccd1 net40 sky130_fd_sc_hd__dlygate4sd3_1
XFILLER_0_69_263 vssd1 vssd1 vccd1 vccd1 sky130_fd_sc_hd__decap_3
XFILLER_0_71_39 vssd1 vssd1 vccd1 vccd1 sky130_fd_sc_hd__decap_4
XFILLER_0_29_138 vssd1 vssd1 vccd1 vccd1 sky130_fd_sc_hd__decap_6
XFILLER_0_57_447 vssd1 vssd1 vccd1 vccd1 sky130_fd_sc_hd__fill_1
XFILLER_0_72_439 vccd1 vssd1 vccd1 vssd1 sky130_ef_sc_hd__decap_12
XFILLER_0_72_417 vssd1 vssd1 vccd1 vccd1 sky130_fd_sc_hd__decap_3
XFILLER_0_25_322 vccd1 vssd1 vccd1 vssd1 sky130_ef_sc_hd__decap_12
XFILLER_0_25_377 vssd1 vssd1 vccd1 vccd1 sky130_fd_sc_hd__decap_8
XFILLER_0_20_65 vccd1 vssd1 vccd1 vssd1 sky130_ef_sc_hd__decap_12
XFILLER_0_25_388 vssd1 vssd1 vccd1 vccd1 sky130_fd_sc_hd__decap_4
Xhold418 u_core.u_regfile.rf\[4\]\[29\] vssd1 vssd1 vccd1 vccd1 net451 sky130_fd_sc_hd__dlygate4sd3_1
Xhold407 u_core.u_regfile.rf\[1\]\[29\] vssd1 vssd1 vccd1 vccd1 net440 sky130_fd_sc_hd__dlygate4sd3_1
XFILLER_0_52_174 vssd1 vssd1 vccd1 vccd1 sky130_fd_sc_hd__decap_4
X_4470_ clknet_leaf_22_clk _0271_ vssd1 vssd1 vccd1 vccd1 u_core.u_regfile.rf\[30\]\[0\]
+ sky130_fd_sc_hd__dfxtp_1
X_3421_ _0637_ _1680_ _1699_ vssd1 vssd1 vccd1 vccd1 _0180_ sky130_fd_sc_hd__a21oi_1
Xhold429 u_audio.sample_reg\[1\] vssd1 vssd1 vccd1 vccd1 net462 sky130_fd_sc_hd__dlygate4sd3_1
XFILLER_0_0_433 vccd1 vssd1 vccd1 vssd1 sky130_ef_sc_hd__decap_12
X_3352_ _1482_ _1666_ _1667_ net38 vssd1 vssd1 vccd1 vccd1 _0143_ sky130_fd_sc_hd__o31a_1
XTAP_701 vssd1 vccd1 sky130_fd_sc_hd__tapvpwrvgnd_1
XFILLER_0_0_477 vccd1 vssd1 vccd1 vssd1 sky130_ef_sc_hd__decap_12
X_2303_ _0760_ vssd1 vssd1 vccd1 vccd1 _0761_ sky130_fd_sc_hd__clkbuf_4
XFILLER_0_29_41 vccd1 vssd1 vccd1 vssd1 sky130_ef_sc_hd__decap_12
XTAP_712 vssd1 vccd1 sky130_fd_sc_hd__tapvpwrvgnd_1
XTAP_723 vssd1 vccd1 sky130_fd_sc_hd__tapvpwrvgnd_1
XTAP_734 vssd1 vccd1 sky130_fd_sc_hd__tapvpwrvgnd_1
X_3283_ _1486_ vssd1 vssd1 vccd1 vccd1 _1633_ sky130_fd_sc_hd__buf_2
XTAP_745 vssd1 vccd1 sky130_fd_sc_hd__tapvpwrvgnd_1
XTAP_756 vssd1 vccd1 sky130_fd_sc_hd__tapvpwrvgnd_1
XTAP_767 vssd1 vccd1 sky130_fd_sc_hd__tapvpwrvgnd_1
X_2234_ _0685_ _0686_ _0691_ vssd1 vssd1 vccd1 vccd1 _0692_ sky130_fd_sc_hd__o21ai_2
XTAP_778 vssd1 vccd1 sky130_fd_sc_hd__tapvpwrvgnd_1
XTAP_789 vssd1 vccd1 sky130_fd_sc_hd__tapvpwrvgnd_1
X_2165_ u_timer.count_reg\[10\] _0620_ _0622_ _0623_ vssd1 vssd1 vccd1 vccd1 _0624_
+ sky130_fd_sc_hd__o211a_1
XFILLER_0_45_73 vssd1 vssd1 vccd1 vccd1 sky130_fd_sc_hd__fill_1
XFILLER_0_75_222 vssd1 vssd1 vccd1 vccd1 sky130_fd_sc_hd__fill_2
XFILLER_0_75_233 vssd1 vssd1 vccd1 vccd1 sky130_fd_sc_hd__fill_1
XFILLER_0_8_500 vssd1 vssd1 vccd1 vccd1 sky130_fd_sc_hd__decap_8
XFILLER_0_0_53 vssd1 vssd1 vccd1 vccd1 sky130_fd_sc_hd__decap_3
XFILLER_0_0_97 vccd1 vssd1 vccd1 vssd1 sky130_ef_sc_hd__decap_12
X_4806_ clknet_leaf_10_clk _0574_ net22 vssd1 vssd1 vccd1 vccd1 u_audio.sample_reg\[7\]
+ sky130_fd_sc_hd__dfrtp_1
X_2998_ _1455_ _1004_ _1446_ _1003_ vssd1 vssd1 vccd1 vccd1 _1456_ sky130_fd_sc_hd__o211ai_2
X_4737_ clknet_leaf_12_clk _0032_ net24 vssd1 vssd1 vccd1 vccd1 u_timer.count_reg\[3\]
+ sky130_fd_sc_hd__dfrtp_2
XFILLER_0_9_51 vssd1 vssd1 vccd1 vccd1 sky130_fd_sc_hd__decap_4
XFILLER_0_71_494 vssd1 vssd1 vccd1 vccd1 sky130_fd_sc_hd__decap_8
XFILLER_0_9_95 vssd1 vssd1 vccd1 vccd1 sky130_fd_sc_hd__fill_1
XFILLER_0_43_174 vssd1 vssd1 vccd1 vccd1 sky130_fd_sc_hd__decap_3
X_4668_ clknet_leaf_24_clk _0469_ vssd1 vssd1 vccd1 vccd1 u_core.u_regfile.rf\[24\]\[6\]
+ sky130_fd_sc_hd__dfxtp_1
XFILLER_0_43_196 vccd1 vssd1 vccd1 vssd1 sky130_ef_sc_hd__decap_12
X_3619_ net271 vssd1 vssd1 vccd1 vccd1 _1802_ sky130_fd_sc_hd__clkbuf_1
X_4599_ clknet_leaf_45_clk _0400_ vssd1 vssd1 vccd1 vccd1 u_core.u_regfile.rf\[1\]\[1\]
+ sky130_fd_sc_hd__dfxtp_1
XFILLER_0_3_293 vccd1 vssd1 vccd1 vssd1 sky130_ef_sc_hd__decap_12
XFILLER_0_54_417 vssd1 vssd1 vccd1 vccd1 sky130_fd_sc_hd__decap_3
XFILLER_0_81_225 vssd1 vssd1 vccd1 vccd1 sky130_fd_sc_hd__fill_2
XFILLER_0_1_208 vccd1 vssd1 vccd1 vssd1 sky130_ef_sc_hd__decap_12
XFILLER_0_82_27 vssd1 vssd1 vccd1 vccd1 sky130_fd_sc_hd__fill_1
XFILLER_0_77_509 vssd1 vssd1 vccd1 vccd1 sky130_fd_sc_hd__fill_1
X_3970_ net278 vssd1 vssd1 vccd1 vccd1 _1981_ sky130_fd_sc_hd__clkbuf_1
X_2921_ _1377_ _1378_ vssd1 vssd1 vccd1 vccd1 _1379_ sky130_fd_sc_hd__nand2_1
XFILLER_0_17_119 vssd1 vssd1 vccd1 vccd1 sky130_fd_sc_hd__fill_1
XFILLER_0_45_428 vssd1 vssd1 vccd1 vccd1 sky130_fd_sc_hd__fill_1
X_2852_ _1309_ _0712_ _0717_ vssd1 vssd1 vccd1 vccd1 _1310_ sky130_fd_sc_hd__and3_1
X_2783_ u_core.u_regfile.rf\[7\]\[23\] _0907_ _0756_ vssd1 vssd1 vccd1 vccd1 _1241_
+ sky130_fd_sc_hd__a21oi_1
XFILLER_0_53_461 vssd1 vssd1 vccd1 vccd1 sky130_fd_sc_hd__fill_1
X_4522_ clknet_leaf_32_clk _0323_ vssd1 vssd1 vccd1 vccd1 u_core.u_regfile.rf\[2\]\[20\]
+ sky130_fd_sc_hd__dfxtp_1
XFILLER_0_53_494 vssd1 vssd1 vccd1 vccd1 sky130_fd_sc_hd__fill_2
Xhold215 u_core.u_regfile.rf\[30\]\[9\] vssd1 vssd1 vccd1 vccd1 net248 sky130_fd_sc_hd__dlygate4sd3_1
X_4453_ clknet_leaf_50_clk _0254_ vssd1 vssd1 vccd1 vccd1 u_core.u_regfile.rf\[7\]\[15\]
+ sky130_fd_sc_hd__dfxtp_1
Xhold226 u_core.u_regfile.rf\[3\]\[9\] vssd1 vssd1 vccd1 vccd1 net259 sky130_fd_sc_hd__dlygate4sd3_1
Xhold204 u_core.u_regfile.rf\[30\]\[14\] vssd1 vssd1 vccd1 vccd1 net237 sky130_fd_sc_hd__dlygate4sd3_1
X_3404_ _0643_ _1680_ _1687_ vssd1 vssd1 vccd1 vccd1 _0175_ sky130_fd_sc_hd__a21oi_1
Xhold259 u_core.u_regfile.rf\[25\]\[26\] vssd1 vssd1 vccd1 vccd1 net292 sky130_fd_sc_hd__dlygate4sd3_1
Xhold237 u_core.u_regfile.rf\[27\]\[2\] vssd1 vssd1 vccd1 vccd1 net270 sky130_fd_sc_hd__dlygate4sd3_1
Xhold248 u_core.u_regfile.rf\[30\]\[29\] vssd1 vssd1 vccd1 vccd1 net281 sky130_fd_sc_hd__dlygate4sd3_1
XFILLER_0_40_188 vssd1 vssd1 vccd1 vccd1 sky130_fd_sc_hd__fill_2
X_4384_ clknet_leaf_19_clk _0195_ net30 vssd1 vssd1 vccd1 vccd1 u_timer.threshold_reg\[20\]
+ sky130_fd_sc_hd__dfrtp_1
XTAP_520 vssd1 vccd1 sky130_fd_sc_hd__tapvpwrvgnd_1
X_3335_ _1658_ vssd1 vssd1 vccd1 vccd1 _0135_ sky130_fd_sc_hd__clkbuf_1
XTAP_531 vssd1 vccd1 sky130_fd_sc_hd__tapvpwrvgnd_1
XTAP_542 vssd1 vccd1 sky130_fd_sc_hd__tapvpwrvgnd_1
X_3266_ _1626_ _1627_ _1628_ net127 vssd1 vssd1 vccd1 vccd1 _0096_ sky130_fd_sc_hd__o31a_1
XTAP_553 vssd1 vccd1 sky130_fd_sc_hd__tapvpwrvgnd_1
XTAP_564 vssd1 vccd1 sky130_fd_sc_hd__tapvpwrvgnd_1
XTAP_575 vssd1 vccd1 sky130_fd_sc_hd__tapvpwrvgnd_1
X_2217_ _0675_ _0607_ _0662_ _0609_ vssd1 vssd1 vccd1 vccd1 _0676_ sky130_fd_sc_hd__o22a_1
XTAP_586 vssd1 vccd1 sky130_fd_sc_hd__tapvpwrvgnd_1
XTAP_597 vssd1 vccd1 sky130_fd_sc_hd__tapvpwrvgnd_1
X_3197_ u_core.u_regfile.rf\[31\]\[9\] vssd1 vssd1 vccd1 vccd1 _1600_ sky130_fd_sc_hd__clkbuf_1
XFILLER_0_22_3 vccd1 vssd1 vccd1 vssd1 sky130_ef_sc_hd__decap_12
XFILLER_0_56_94 vssd1 vssd1 vccd1 vccd1 sky130_fd_sc_hd__fill_1
X_2148_ u_timer.count_reg\[19\] _0603_ vssd1 vssd1 vccd1 vccd1 _0607_ sky130_fd_sc_hd__nor2_1
XFILLER_0_72_93 vssd1 vssd1 vccd1 vccd1 sky130_fd_sc_hd__fill_1
XFILLER_0_48_244 vssd1 vssd1 vccd1 vccd1 sky130_fd_sc_hd__decap_8
XFILLER_0_8_363 vssd1 vssd1 vccd1 vccd1 sky130_fd_sc_hd__fill_1
XFILLER_0_48_299 vssd1 vssd1 vccd1 vccd1 sky130_fd_sc_hd__fill_1
XFILLER_0_16_130 vssd1 vssd1 vccd1 vccd1 sky130_fd_sc_hd__decap_4
XFILLER_0_31_166 vssd1 vssd1 vccd1 vccd1 sky130_fd_sc_hd__fill_2
XFILLER_0_59_509 vssd1 vssd1 vccd1 vccd1 sky130_fd_sc_hd__fill_1
XFILLER_0_82_501 vssd1 vssd1 vccd1 vccd1 sky130_fd_sc_hd__decap_8
XFILLER_0_42_409 vssd1 vssd1 vccd1 vccd1 sky130_fd_sc_hd__decap_3
XFILLER_0_77_27 vccd1 vssd1 vccd1 vssd1 sky130_ef_sc_hd__decap_12
XFILLER_0_10_317 vssd1 vssd1 vccd1 vccd1 sky130_fd_sc_hd__fill_1
XFILLER_0_50_464 vssd1 vssd1 vccd1 vccd1 sky130_fd_sc_hd__fill_1
XFILLER_0_50_475 vssd1 vssd1 vccd1 vccd1 sky130_fd_sc_hd__fill_1
X_3120_ _1546_ _1495_ _1547_ vssd1 vssd1 vccd1 vccd1 _1548_ sky130_fd_sc_hd__and3b_1
X_3051_ _1498_ _1499_ _0684_ vssd1 vssd1 vccd1 vccd1 _1500_ sky130_fd_sc_hd__and3b_1
XFILLER_0_85_361 vssd1 vssd1 vccd1 vccd1 sky130_fd_sc_hd__decap_3
X_3953_ _1972_ vssd1 vssd1 vccd1 vccd1 _0439_ sky130_fd_sc_hd__clkbuf_1
X_3884_ net450 vssd1 vssd1 vccd1 vccd1 _1938_ sky130_fd_sc_hd__clkbuf_1
XFILLER_0_42_85 vssd1 vssd1 vccd1 vccd1 sky130_fd_sc_hd__fill_2
XFILLER_0_45_236 vssd1 vssd1 vccd1 vccd1 sky130_fd_sc_hd__fill_1
X_2904_ _0782_ _1214_ _1210_ _1220_ vssd1 vssd1 vccd1 vccd1 _1362_ sky130_fd_sc_hd__nor4b_1
XFILLER_0_45_258 vssd1 vssd1 vccd1 vccd1 sky130_fd_sc_hd__fill_1
X_2835_ _1281_ _1283_ _1284_ _1292_ vssd1 vssd1 vccd1 vccd1 _1293_ sky130_fd_sc_hd__a211oi_4
X_2766_ _1221_ _1223_ vssd1 vssd1 vccd1 vccd1 _1224_ sky130_fd_sc_hd__nor2_1
XFILLER_0_13_166 vssd1 vssd1 vccd1 vccd1 sky130_fd_sc_hd__fill_2
X_2697_ u_core.u_regfile.rf\[7\]\[19\] _0907_ vssd1 vssd1 vccd1 vccd1 _1155_ sky130_fd_sc_hd__nand2_1
X_4505_ clknet_leaf_32_clk _0306_ vssd1 vssd1 vccd1 vccd1 u_core.u_regfile.rf\[2\]\[3\]
+ sky130_fd_sc_hd__dfxtp_1
X_4436_ clknet_leaf_9_clk _0046_ net22 vssd1 vssd1 vccd1 vccd1 u_audio.counter\[7\]
+ sky130_fd_sc_hd__dfrtp_1
X_4367_ clknet_leaf_12_clk _0178_ net26 vssd1 vssd1 vccd1 vccd1 u_timer.threshold_reg\[3\]
+ sky130_fd_sc_hd__dfstp_1
X_3318_ net397 vssd1 vssd1 vccd1 vccd1 _1650_ sky130_fd_sc_hd__clkbuf_1
XFILLER_0_6_85 vssd1 vssd1 vccd1 vccd1 sky130_fd_sc_hd__fill_1
XTAP_350 vssd1 vccd1 sky130_fd_sc_hd__tapvpwrvgnd_1
XTAP_361 vssd1 vccd1 sky130_fd_sc_hd__tapvpwrvgnd_1
XTAP_372 vssd1 vccd1 sky130_fd_sc_hd__tapvpwrvgnd_1
X_4298_ clknet_leaf_1_clk _0109_ vssd1 vssd1 vccd1 vccd1 u_core.u_regfile.rf\[6\]\[30\]
+ sky130_fd_sc_hd__dfxtp_1
XTAP_383 vssd1 vccd1 sky130_fd_sc_hd__tapvpwrvgnd_1
XTAP_394 vssd1 vccd1 sky130_fd_sc_hd__tapvpwrvgnd_1
X_3249_ _1623_ _1624_ _1625_ net133 vssd1 vssd1 vccd1 vccd1 _0082_ sky130_fd_sc_hd__o31a_1
XFILLER_0_83_81 vccd1 vssd1 vccd1 vssd1 sky130_ef_sc_hd__decap_12
XPHY_12 vssd1 vssd1 vccd1 vccd1 sky130_fd_sc_hd__decap_3
XPHY_34 vssd1 vssd1 vccd1 vccd1 sky130_fd_sc_hd__decap_3
XPHY_23 vssd1 vssd1 vccd1 vccd1 sky130_fd_sc_hd__decap_3
XPHY_45 vssd1 vssd1 vccd1 vccd1 sky130_fd_sc_hd__decap_3
XPHY_56 vssd1 vssd1 vccd1 vccd1 sky130_fd_sc_hd__decap_3
XPHY_67 vssd1 vssd1 vccd1 vccd1 sky130_fd_sc_hd__decap_3
XPHY_78 vssd1 vssd1 vccd1 vccd1 sky130_fd_sc_hd__decap_3
XPHY_89 vssd1 vssd1 vccd1 vccd1 sky130_fd_sc_hd__decap_3
XFILLER_0_64_501 vssd1 vssd1 vccd1 vccd1 sky130_fd_sc_hd__decap_8
XFILLER_0_32_475 vssd1 vssd1 vccd1 vccd1 sky130_fd_sc_hd__fill_1
XFILLER_0_74_309 vccd1 vssd1 vccd1 vssd1 sky130_ef_sc_hd__decap_12
XFILLER_0_27_225 vssd1 vssd1 vccd1 vccd1 sky130_fd_sc_hd__decap_3
XFILLER_0_82_353 vssd1 vssd1 vccd1 vccd1 sky130_fd_sc_hd__decap_8
X_2620_ _1076_ _0697_ _0733_ _0904_ _1077_ vssd1 vssd1 vccd1 vccd1 _1078_ sky130_fd_sc_hd__o221ai_1
XFILLER_0_23_420 vssd1 vssd1 vccd1 vccd1 sky130_fd_sc_hd__fill_1
XFILLER_0_23_431 vssd1 vssd1 vccd1 vccd1 sky130_fd_sc_hd__decap_8
X_2551_ u_core.u_regfile.rf\[31\]\[3\] _0726_ _0874_ _0738_ vssd1 vssd1 vccd1 vccd1
+ _1009_ sky130_fd_sc_hd__a2bb2o_2
X_2482_ _0860_ u_core.u_regfile.rf\[7\]\[9\] _0861_ vssd1 vssd1 vccd1 vccd1 _0940_
+ sky130_fd_sc_hd__nand3_1
XFILLER_0_23_497 vssd1 vssd1 vccd1 vccd1 sky130_fd_sc_hd__decap_6
X_4221_ _1566_ _1481_ _2110_ vssd1 vssd1 vccd1 vccd1 _0569_ sky130_fd_sc_hd__a21oi_1
X_4152_ net144 vssd1 vssd1 vccd1 vccd1 _2076_ sky130_fd_sc_hd__clkbuf_1
XFILLER_0_37_30 vssd1 vssd1 vccd1 vccd1 sky130_fd_sc_hd__fill_2
X_3103_ u_timer.count_reg\[18\] u_timer.count_reg\[17\] u_timer.count_reg\[16\] _1533_
+ vssd1 vssd1 vccd1 vccd1 _1536_ sky130_fd_sc_hd__and4_1
X_4083_ _2037_ vssd1 vssd1 vccd1 vccd1 _0504_ sky130_fd_sc_hd__clkbuf_1
XFILLER_0_37_52 vssd1 vssd1 vccd1 vccd1 sky130_fd_sc_hd__decap_4
X_3034_ _1405_ _1484_ _1486_ _1487_ vssd1 vssd1 vccd1 vccd1 _1488_ sky130_fd_sc_hd__a31o_1
X_3936_ net160 vssd1 vssd1 vccd1 vccd1 _1964_ sky130_fd_sc_hd__clkbuf_1
X_3867_ _1929_ vssd1 vssd1 vccd1 vccd1 _0396_ sky130_fd_sc_hd__clkbuf_1
XFILLER_0_73_364 vccd1 vssd1 vccd1 vssd1 sky130_ef_sc_hd__decap_12
X_2818_ _1236_ _1237_ vssd1 vssd1 vccd1 vccd1 _1276_ sky130_fd_sc_hd__and2_1
X_3798_ _1876_ _1862_ net117 vssd1 vssd1 vccd1 vccd1 _1895_ sky130_fd_sc_hd__o21ai_1
XFILLER_0_14_475 vssd1 vssd1 vccd1 vccd1 sky130_fd_sc_hd__fill_1
X_2749_ _0965_ _1198_ _1204_ _1203_ vssd1 vssd1 vccd1 vccd1 _1207_ sky130_fd_sc_hd__a31oi_4
XFILLER_0_41_250 vssd1 vssd1 vccd1 vccd1 sky130_fd_sc_hd__decap_6
XFILLER_0_1_391 vssd1 vssd1 vccd1 vccd1 sky130_fd_sc_hd__fill_1
X_4419_ clknet_leaf_27_clk _0230_ vssd1 vssd1 vccd1 vccd1 u_core.u_regfile.rf\[29\]\[23\]
+ sky130_fd_sc_hd__dfxtp_1
XTAP_180 vssd1 vccd1 sky130_fd_sc_hd__tapvpwrvgnd_1
XTAP_191 vssd1 vccd1 sky130_fd_sc_hd__tapvpwrvgnd_1
XFILLER_0_68_136 vssd1 vssd1 vccd1 vccd1 sky130_fd_sc_hd__decap_4
XFILLER_0_58_29 vccd1 vssd1 vccd1 vssd1 sky130_ef_sc_hd__decap_12
XFILLER_0_59_136 vssd1 vssd1 vccd1 vccd1 sky130_fd_sc_hd__fill_1
XFILLER_0_47_309 vccd1 vssd1 vccd1 vssd1 sky130_ef_sc_hd__decap_12
XFILLER_0_74_128 vssd1 vssd1 vccd1 vccd1 sky130_fd_sc_hd__fill_1
X_4770_ clknet_leaf_33_clk _0538_ vssd1 vssd1 vccd1 vccd1 u_core.u_regfile.rf\[3\]\[3\]
+ sky130_fd_sc_hd__dfxtp_1
XFILLER_0_15_217 vssd1 vssd1 vccd1 vccd1 sky130_fd_sc_hd__fill_1
X_3721_ net202 vssd1 vssd1 vccd1 vccd1 _1853_ sky130_fd_sc_hd__clkbuf_1
X_3652_ _1818_ vssd1 vssd1 vccd1 vccd1 _0292_ sky130_fd_sc_hd__clkbuf_1
X_3583_ _0778_ vssd1 vssd1 vccd1 vccd1 _1793_ sky130_fd_sc_hd__clkbuf_4
X_2603_ _0696_ _1059_ _1060_ vssd1 vssd1 vccd1 vccd1 _1061_ sky130_fd_sc_hd__o21ai_1
X_2534_ _0922_ _0989_ _0761_ _0749_ _0991_ vssd1 vssd1 vccd1 vccd1 _0992_ sky130_fd_sc_hd__o311ai_4
XFILLER_0_2_133 vssd1 vssd1 vccd1 vccd1 sky130_fd_sc_hd__fill_1
XFILLER_0_2_177 vssd1 vssd1 vccd1 vccd1 sky130_fd_sc_hd__decap_3
X_2465_ _0922_ _0761_ u_core.u_regfile.rf\[6\]\[15\] vssd1 vssd1 vccd1 vccd1 _0923_
+ sky130_fd_sc_hd__o21ai_1
X_4204_ net203 vssd1 vssd1 vccd1 vccd1 _2102_ sky130_fd_sc_hd__clkbuf_1
X_2396_ _0730_ _0740_ u_core.u_regfile.rf\[28\]\[14\] vssd1 vssd1 vccd1 vccd1 _0854_
+ sky130_fd_sc_hd__o21a_1
X_4135_ _2065_ _1737_ _1686_ vssd1 vssd1 vccd1 vccd1 _2066_ sky130_fd_sc_hd__nand3b_1
X_4066_ net263 vssd1 vssd1 vccd1 vccd1 _2029_ sky130_fd_sc_hd__clkbuf_1
XFILLER_0_78_445 vssd1 vssd1 vccd1 vccd1 sky130_fd_sc_hd__decap_8
X_3017_ _0794_ _0792_ vssd1 vssd1 vccd1 vccd1 _1475_ sky130_fd_sc_hd__or2_1
XFILLER_0_64_83 vssd1 vssd1 vccd1 vccd1 sky130_fd_sc_hd__fill_1
XFILLER_0_38_309 vssd1 vssd1 vccd1 vccd1 sky130_fd_sc_hd__decap_4
X_3919_ _1955_ vssd1 vssd1 vccd1 vccd1 _0422_ sky130_fd_sc_hd__clkbuf_1
XFILLER_0_34_504 vssd1 vssd1 vccd1 vccd1 sky130_fd_sc_hd__decap_6
XFILLER_0_61_378 vssd1 vssd1 vccd1 vccd1 sky130_fd_sc_hd__decap_8
XFILLER_0_69_445 vssd1 vssd1 vccd1 vccd1 sky130_fd_sc_hd__decap_3
XFILLER_0_64_161 vssd1 vssd1 vccd1 vccd1 sky130_fd_sc_hd__fill_1
XTAP_916 vssd1 vccd1 sky130_fd_sc_hd__tapvpwrvgnd_1
XTAP_905 vssd1 vccd1 sky130_fd_sc_hd__tapvpwrvgnd_1
XFILLER_0_20_253 vssd1 vssd1 vccd1 vccd1 sky130_fd_sc_hd__decap_4
XTAP_949 vssd1 vccd1 sky130_fd_sc_hd__tapvpwrvgnd_1
XFILLER_0_85_27 vssd1 vssd1 vccd1 vccd1 sky130_fd_sc_hd__fill_1
XTAP_938 vssd1 vccd1 sky130_fd_sc_hd__tapvpwrvgnd_1
XTAP_927 vssd1 vccd1 sky130_fd_sc_hd__tapvpwrvgnd_1
X_2250_ u_core.u_regfile.rf\[29\]\[29\] u_core.u_regfile.rf\[31\]\[29\] _0707_ vssd1
+ vssd1 vccd1 vccd1 _0708_ sky130_fd_sc_hd__mux2_1
X_2181_ net219 vssd1 vssd1 vccd1 vccd1 _0640_ sky130_fd_sc_hd__inv_2
XFILLER_0_79_209 vccd1 vssd1 vccd1 vssd1 sky130_ef_sc_hd__decap_12
X_4753_ clknet_leaf_21_clk net485 net31 vssd1 vssd1 vccd1 vccd1 u_timer.count_reg\[19\]
+ sky130_fd_sc_hd__dfrtp_2
XFILLER_0_7_247 vssd1 vssd1 vccd1 vccd1 sky130_fd_sc_hd__decap_8
XFILLER_0_55_150 vssd1 vssd1 vccd1 vccd1 sky130_fd_sc_hd__fill_2
X_3704_ _1844_ vssd1 vssd1 vccd1 vccd1 _0318_ sky130_fd_sc_hd__clkbuf_1
X_4684_ clknet_leaf_33_clk _0485_ vssd1 vssd1 vccd1 vccd1 u_core.u_regfile.rf\[24\]\[22\]
+ sky130_fd_sc_hd__dfxtp_1
XFILLER_0_70_153 vccd1 vssd1 vccd1 vssd1 sky130_ef_sc_hd__decap_12
X_3635_ net239 vssd1 vssd1 vccd1 vccd1 _1810_ sky130_fd_sc_hd__clkbuf_1
XFILLER_0_70_197 vssd1 vssd1 vccd1 vccd1 sky130_fd_sc_hd__fill_2
XFILLER_0_3_497 vssd1 vssd1 vccd1 vccd1 sky130_fd_sc_hd__decap_6
X_3566_ net410 vssd1 vssd1 vccd1 vccd1 _1788_ sky130_fd_sc_hd__clkbuf_1
X_3497_ _1683_ _1413_ _1713_ _1480_ _0582_ vssd1 vssd1 vccd1 vccd1 _1753_ sky130_fd_sc_hd__a41o_1
X_2517_ u_core.u_regfile.rf\[29\]\[10\] u_core.u_regfile.rf\[31\]\[10\] _0704_ vssd1
+ vssd1 vccd1 vccd1 _0975_ sky130_fd_sc_hd__mux2_1
X_2448_ _0900_ _0902_ _0905_ vssd1 vssd1 vccd1 vccd1 _0906_ sky130_fd_sc_hd__o21ai_2
XFILLER_0_52_3 vccd1 vssd1 vccd1 vssd1 sky130_ef_sc_hd__decap_12
X_2379_ u_core.u_regfile.rf\[1\]\[24\] _0743_ _0759_ _0711_ vssd1 vssd1 vccd1 vccd1
+ _0837_ sky130_fd_sc_hd__o2bb2a_1
XFILLER_0_75_93 vccd1 vssd1 vccd1 vssd1 sky130_ef_sc_hd__decap_12
X_4118_ net205 vssd1 vssd1 vccd1 vccd1 _2055_ sky130_fd_sc_hd__clkbuf_1
X_4049_ _2020_ vssd1 vssd1 vccd1 vccd1 _0487_ sky130_fd_sc_hd__clkbuf_1
XFILLER_0_78_297 vssd1 vssd1 vccd1 vccd1 sky130_fd_sc_hd__decap_8
XFILLER_0_38_106 vssd1 vssd1 vccd1 vccd1 sky130_fd_sc_hd__fill_2
XFILLER_0_81_429 vccd1 vssd1 vccd1 vssd1 sky130_ef_sc_hd__decap_12
XFILLER_0_53_109 vssd1 vssd1 vccd1 vccd1 sky130_fd_sc_hd__decap_3
XFILLER_0_6_280 vssd1 vssd1 vccd1 vccd1 sky130_fd_sc_hd__decap_4
XFILLER_0_6_291 vssd1 vssd1 vccd1 vccd1 sky130_fd_sc_hd__fill_1
Xhold8 u_core.u_regfile.rf\[28\]\[2\] vssd1 vssd1 vccd1 vccd1 net41 sky130_fd_sc_hd__dlygate4sd3_1
XFILLER_0_29_106 vssd1 vssd1 vccd1 vccd1 sky130_fd_sc_hd__fill_1
XFILLER_0_84_256 vssd1 vssd1 vccd1 vccd1 sky130_fd_sc_hd__decap_8
XFILLER_0_72_429 vssd1 vssd1 vccd1 vccd1 sky130_fd_sc_hd__fill_2
XFILLER_0_25_334 vssd1 vssd1 vccd1 vccd1 sky130_fd_sc_hd__fill_2
XFILLER_0_37_183 vssd1 vssd1 vccd1 vccd1 sky130_fd_sc_hd__decap_3
Xhold408 u_core.u_regfile.rf\[4\]\[9\] vssd1 vssd1 vccd1 vccd1 net441 sky130_fd_sc_hd__dlygate4sd3_1
XFILLER_0_20_77 vssd1 vssd1 vccd1 vccd1 sky130_fd_sc_hd__decap_6
XFILLER_0_40_326 vssd1 vssd1 vccd1 vccd1 sky130_fd_sc_hd__fill_1
Xhold419 u_core.u_regfile.rf\[28\]\[13\] vssd1 vssd1 vccd1 vccd1 net452 sky130_fd_sc_hd__dlygate4sd3_1
X_3420_ _1697_ _1698_ _1678_ _1694_ _1695_ vssd1 vssd1 vccd1 vccd1 _1699_ sky130_fd_sc_hd__o2111a_1
XFILLER_0_0_445 vssd1 vssd1 vccd1 vccd1 sky130_fd_sc_hd__decap_3
X_3351_ _0898_ vssd1 vssd1 vccd1 vccd1 _1667_ sky130_fd_sc_hd__clkbuf_4
XFILLER_0_0_489 vccd1 vssd1 vccd1 vssd1 sky130_ef_sc_hd__decap_12
X_2302_ u_imem.addr\[5\] u_imem.addr\[4\] u_imem.addr\[3\] vssd1 vssd1 vccd1 vccd1
+ _0760_ sky130_fd_sc_hd__nor3b_1
XFILLER_0_29_53 vssd1 vssd1 vccd1 vccd1 sky130_fd_sc_hd__decap_3
XTAP_702 vssd1 vccd1 sky130_fd_sc_hd__tapvpwrvgnd_1
XTAP_713 vssd1 vccd1 sky130_fd_sc_hd__tapvpwrvgnd_1
XTAP_724 vssd1 vccd1 sky130_fd_sc_hd__tapvpwrvgnd_1
X_3282_ _1487_ vssd1 vssd1 vccd1 vccd1 _1632_ sky130_fd_sc_hd__buf_2
XTAP_735 vssd1 vccd1 sky130_fd_sc_hd__tapvpwrvgnd_1
XTAP_746 vssd1 vccd1 sky130_fd_sc_hd__tapvpwrvgnd_1
XTAP_757 vssd1 vccd1 sky130_fd_sc_hd__tapvpwrvgnd_1
XTAP_768 vssd1 vccd1 sky130_fd_sc_hd__tapvpwrvgnd_1
X_2233_ _0687_ u_imem.addr\[4\] _0689_ _0690_ vssd1 vssd1 vccd1 vccd1 _0691_ sky130_fd_sc_hd__o22ai_4
XFILLER_0_29_97 vssd1 vssd1 vccd1 vccd1 sky130_fd_sc_hd__decap_3
XTAP_779 vssd1 vccd1 sky130_fd_sc_hd__tapvpwrvgnd_1
X_2164_ u_timer.count_reg\[11\] _0621_ vssd1 vssd1 vccd1 vccd1 _0623_ sky130_fd_sc_hd__or2_1
XFILLER_0_0_21 vssd1 vssd1 vccd1 vccd1 sky130_fd_sc_hd__decap_6
XFILLER_0_48_448 vssd1 vssd1 vccd1 vccd1 sky130_fd_sc_hd__fill_1
X_4805_ clknet_leaf_9_clk _0573_ net22 vssd1 vssd1 vccd1 vccd1 u_audio.sample_reg\[6\]
+ sky130_fd_sc_hd__dfrtp_1
XFILLER_0_28_172 vssd1 vssd1 vccd1 vccd1 sky130_fd_sc_hd__fill_1
X_2997_ _1005_ vssd1 vssd1 vccd1 vccd1 _1455_ sky130_fd_sc_hd__inv_2
X_4736_ clknet_leaf_12_clk _0029_ net24 vssd1 vssd1 vccd1 vccd1 u_timer.count_reg\[2\]
+ sky130_fd_sc_hd__dfrtp_2
XFILLER_0_71_440 vssd1 vssd1 vccd1 vccd1 sky130_fd_sc_hd__fill_1
XFILLER_0_28_194 vssd1 vssd1 vccd1 vccd1 sky130_fd_sc_hd__fill_2
XFILLER_0_43_120 vssd1 vssd1 vccd1 vccd1 sky130_fd_sc_hd__decap_4
X_4667_ clknet_leaf_36_clk _0468_ vssd1 vssd1 vccd1 vccd1 u_core.u_regfile.rf\[24\]\[5\]
+ sky130_fd_sc_hd__dfxtp_1
XFILLER_0_31_304 vccd1 vssd1 vccd1 vssd1 sky130_ef_sc_hd__decap_12
X_3618_ _1801_ vssd1 vssd1 vccd1 vccd1 _0275_ sky130_fd_sc_hd__clkbuf_1
X_4598_ clknet_leaf_3_clk _0399_ vssd1 vssd1 vccd1 vccd1 u_core.u_regfile.rf\[1\]\[0\]
+ sky130_fd_sc_hd__dfxtp_1
X_3549_ _1779_ vssd1 vssd1 vccd1 vccd1 _0228_ sky130_fd_sc_hd__clkbuf_1
XFILLER_0_66_223 vssd1 vssd1 vccd1 vccd1 sky130_fd_sc_hd__decap_3
XFILLER_0_66_245 vssd1 vssd1 vccd1 vccd1 sky130_fd_sc_hd__fill_2
XFILLER_0_34_131 vssd1 vssd1 vccd1 vccd1 sky130_fd_sc_hd__fill_1
XFILLER_0_34_197 vssd1 vssd1 vccd1 vccd1 sky130_fd_sc_hd__decap_3
XFILLER_0_66_29 vssd1 vssd1 vccd1 vccd1 sky130_fd_sc_hd__fill_2
Xclkbuf_2_3__f_clk clknet_0_clk vssd1 vssd1 vccd1 vccd1 clknet_2_3__leaf_clk sky130_fd_sc_hd__clkbuf_16
XFILLER_0_15_77 vssd1 vssd1 vccd1 vccd1 sky130_fd_sc_hd__decap_4
X_2920_ _1297_ _1371_ _0833_ _0846_ vssd1 vssd1 vccd1 vccd1 _1378_ sky130_fd_sc_hd__o211ai_2
XFILLER_0_31_21 vssd1 vssd1 vccd1 vccd1 sky130_fd_sc_hd__fill_2
XFILLER_0_57_289 vccd1 vssd1 vccd1 vssd1 sky130_ef_sc_hd__decap_12
X_2851_ u_core.u_regfile.rf\[29\]\[30\] u_core.u_regfile.rf\[31\]\[30\] _0706_ vssd1
+ vssd1 vccd1 vccd1 _1309_ sky130_fd_sc_hd__mux2_1
XFILLER_0_72_248 vssd1 vssd1 vccd1 vccd1 sky130_fd_sc_hd__fill_1
X_2782_ u_core.u_regfile.rf\[6\]\[23\] vssd1 vssd1 vccd1 vccd1 _1240_ sky130_fd_sc_hd__inv_2
XFILLER_0_13_315 vssd1 vssd1 vccd1 vccd1 sky130_fd_sc_hd__decap_4
XFILLER_0_40_101 vssd1 vssd1 vccd1 vccd1 sky130_fd_sc_hd__decap_6
X_4521_ clknet_leaf_26_clk _0322_ vssd1 vssd1 vccd1 vccd1 u_core.u_regfile.rf\[2\]\[19\]
+ sky130_fd_sc_hd__dfxtp_1
Xhold216 u_timer.threshold_reg\[3\] vssd1 vssd1 vccd1 vccd1 net249 sky130_fd_sc_hd__dlygate4sd3_1
X_4452_ clknet_leaf_49_clk _0253_ vssd1 vssd1 vccd1 vccd1 u_core.u_regfile.rf\[7\]\[14\]
+ sky130_fd_sc_hd__dfxtp_1
Xhold205 u_core.u_regfile.rf\[3\]\[25\] vssd1 vssd1 vccd1 vccd1 net238 sky130_fd_sc_hd__dlygate4sd3_1
Xhold227 u_core.u_regfile.rf\[3\]\[29\] vssd1 vssd1 vccd1 vccd1 net260 sky130_fd_sc_hd__dlygate4sd3_1
Xhold249 u_core.u_regfile.rf\[25\]\[24\] vssd1 vssd1 vccd1 vccd1 net282 sky130_fd_sc_hd__dlygate4sd3_1
Xhold238 u_core.u_regfile.rf\[30\]\[5\] vssd1 vssd1 vccd1 vccd1 net271 sky130_fd_sc_hd__dlygate4sd3_1
X_3403_ _1681_ _1682_ _1678_ _1683_ _1686_ vssd1 vssd1 vccd1 vccd1 _1687_ sky130_fd_sc_hd__o2111a_1
XFILLER_0_0_253 vccd1 vssd1 vccd1 vssd1 sky130_ef_sc_hd__decap_12
XFILLER_0_21_381 vssd1 vssd1 vccd1 vccd1 sky130_fd_sc_hd__fill_2
X_4383_ clknet_leaf_19_clk _0194_ net32 vssd1 vssd1 vccd1 vccd1 u_timer.threshold_reg\[19\]
+ sky130_fd_sc_hd__dfrtp_1
XTAP_510 vssd1 vccd1 sky130_fd_sc_hd__tapvpwrvgnd_1
XTAP_521 vssd1 vccd1 sky130_fd_sc_hd__tapvpwrvgnd_1
XTAP_532 vssd1 vccd1 sky130_fd_sc_hd__tapvpwrvgnd_1
X_3334_ net435 vssd1 vssd1 vccd1 vccd1 _1658_ sky130_fd_sc_hd__clkbuf_1
XTAP_543 vssd1 vccd1 sky130_fd_sc_hd__tapvpwrvgnd_1
X_3265_ _1626_ _1627_ _1628_ net128 vssd1 vssd1 vccd1 vccd1 _0095_ sky130_fd_sc_hd__o31a_1
XTAP_554 vssd1 vccd1 sky130_fd_sc_hd__tapvpwrvgnd_1
XTAP_565 vssd1 vccd1 sky130_fd_sc_hd__tapvpwrvgnd_1
XTAP_576 vssd1 vccd1 sky130_fd_sc_hd__tapvpwrvgnd_1
X_2216_ u_timer.threshold_reg\[18\] _0605_ u_timer.threshold_reg\[19\] _0674_ vssd1
+ vssd1 vccd1 vccd1 _0675_ sky130_fd_sc_hd__o22a_1
XTAP_587 vssd1 vccd1 sky130_fd_sc_hd__tapvpwrvgnd_1
XTAP_598 vssd1 vccd1 sky130_fd_sc_hd__tapvpwrvgnd_1
X_3196_ _1599_ vssd1 vssd1 vccd1 vccd1 _0055_ sky130_fd_sc_hd__clkbuf_1
X_2147_ u_timer.count_reg\[17\] vssd1 vssd1 vccd1 vccd1 _0606_ sky130_fd_sc_hd__inv_2
XFILLER_0_15_3 vccd1 vssd1 vccd1 vssd1 sky130_ef_sc_hd__decap_12
XFILLER_0_72_83 vssd1 vssd1 vccd1 vccd1 sky130_fd_sc_hd__fill_1
XFILLER_0_8_320 vccd1 vssd1 vccd1 vssd1 sky130_ef_sc_hd__decap_12
XFILLER_0_44_451 vssd1 vssd1 vccd1 vccd1 sky130_fd_sc_hd__fill_1
X_4719_ clknet_leaf_25_clk _0520_ vssd1 vssd1 vccd1 vccd1 u_core.u_regfile.rf\[25\]\[25\]
+ sky130_fd_sc_hd__dfxtp_1
XFILLER_0_71_281 vssd1 vssd1 vccd1 vccd1 sky130_fd_sc_hd__decap_6
XFILLER_0_27_418 vssd1 vssd1 vccd1 vccd1 sky130_fd_sc_hd__fill_1
XFILLER_0_39_245 vccd1 vssd1 vccd1 vssd1 sky130_ef_sc_hd__decap_12
XFILLER_0_50_421 vssd1 vssd1 vccd1 vccd1 sky130_fd_sc_hd__fill_2
XFILLER_0_77_39 vccd1 vssd1 vccd1 vssd1 sky130_ef_sc_hd__decap_12
X_3050_ u_timer.count_reg\[3\] u_timer.count_reg\[2\] u_timer.count_reg\[1\] u_timer.count_reg\[0\]
+ u_timer.count_reg\[4\] vssd1 vssd1 vccd1 vccd1 _1499_ sky130_fd_sc_hd__a41o_1
XFILLER_0_26_76 vssd1 vssd1 vccd1 vccd1 sky130_fd_sc_hd__fill_1
XFILLER_0_73_502 vssd1 vssd1 vccd1 vccd1 sky130_fd_sc_hd__fill_2
X_3952_ net299 vssd1 vssd1 vccd1 vccd1 _1972_ sky130_fd_sc_hd__clkbuf_1
X_3883_ _1937_ vssd1 vssd1 vccd1 vccd1 _0404_ sky130_fd_sc_hd__clkbuf_1
X_2903_ _0781_ _1222_ _1214_ vssd1 vssd1 vccd1 vccd1 _1361_ sky130_fd_sc_hd__o21a_1
X_2834_ _1272_ _1291_ vssd1 vssd1 vccd1 vccd1 _1292_ sky130_fd_sc_hd__nor2_1
XFILLER_0_5_323 vccd1 vssd1 vccd1 vssd1 sky130_ef_sc_hd__decap_12
XFILLER_0_5_389 vssd1 vssd1 vccd1 vccd1 sky130_fd_sc_hd__decap_3
X_2765_ _0780_ _1222_ _1214_ vssd1 vssd1 vccd1 vccd1 _1223_ sky130_fd_sc_hd__o21ba_1
X_4504_ clknet_leaf_25_clk _0305_ vssd1 vssd1 vccd1 vccd1 u_core.u_regfile.rf\[2\]\[2\]
+ sky130_fd_sc_hd__dfxtp_1
X_2696_ _0808_ _0762_ u_core.u_regfile.rf\[6\]\[19\] vssd1 vssd1 vccd1 vccd1 _1154_
+ sky130_fd_sc_hd__o21ai_1
X_4435_ clknet_leaf_9_clk _0045_ net22 vssd1 vssd1 vccd1 vccd1 u_audio.counter\[6\]
+ sky130_fd_sc_hd__dfrtp_1
X_4366_ clknet_leaf_12_clk _0177_ net26 vssd1 vssd1 vccd1 vccd1 u_timer.threshold_reg\[2\]
+ sky130_fd_sc_hd__dfstp_1
XTAP_340 vssd1 vccd1 sky130_fd_sc_hd__tapvpwrvgnd_1
X_3317_ _1649_ vssd1 vssd1 vccd1 vccd1 _0126_ sky130_fd_sc_hd__clkbuf_1
XTAP_351 vssd1 vccd1 sky130_fd_sc_hd__tapvpwrvgnd_1
XTAP_362 vssd1 vccd1 sky130_fd_sc_hd__tapvpwrvgnd_1
XTAP_373 vssd1 vccd1 sky130_fd_sc_hd__tapvpwrvgnd_1
XTAP_384 vssd1 vccd1 sky130_fd_sc_hd__tapvpwrvgnd_1
X_4297_ clknet_leaf_2_clk _0108_ vssd1 vssd1 vccd1 vccd1 u_core.u_regfile.rf\[6\]\[29\]
+ sky130_fd_sc_hd__dfxtp_1
X_3248_ _1623_ _1624_ _1625_ net68 vssd1 vssd1 vccd1 vccd1 _0081_ sky130_fd_sc_hd__o31a_1
XTAP_395 vssd1 vccd1 sky130_fd_sc_hd__tapvpwrvgnd_1
X_3179_ net510 vssd1 vssd1 vccd1 vccd1 _1591_ sky130_fd_sc_hd__clkbuf_1
XFILLER_0_83_93 vccd1 vssd1 vccd1 vssd1 sky130_ef_sc_hd__decap_12
XPHY_13 vssd1 vssd1 vccd1 vccd1 sky130_fd_sc_hd__decap_3
XFILLER_0_68_307 vssd1 vssd1 vccd1 vccd1 sky130_fd_sc_hd__fill_1
XPHY_35 vssd1 vssd1 vccd1 vccd1 sky130_fd_sc_hd__decap_3
XPHY_24 vssd1 vssd1 vccd1 vccd1 sky130_fd_sc_hd__decap_3
XPHY_46 vssd1 vssd1 vccd1 vccd1 sky130_fd_sc_hd__decap_3
XPHY_57 vssd1 vssd1 vccd1 vccd1 sky130_fd_sc_hd__decap_3
XPHY_68 vssd1 vssd1 vccd1 vccd1 sky130_fd_sc_hd__decap_3
XPHY_79 vssd1 vssd1 vccd1 vccd1 sky130_fd_sc_hd__decap_3
XFILLER_0_51_229 vssd1 vssd1 vccd1 vccd1 sky130_fd_sc_hd__fill_1
XFILLER_0_32_421 vssd1 vssd1 vccd1 vccd1 sky130_fd_sc_hd__decap_3
XFILLER_0_32_443 vssd1 vssd1 vccd1 vccd1 sky130_fd_sc_hd__fill_2
XFILLER_0_4_3 vccd1 vssd1 vccd1 vssd1 sky130_ef_sc_hd__decap_12
XFILLER_0_55_502 vssd1 vssd1 vccd1 vccd1 sky130_fd_sc_hd__fill_2
XFILLER_0_82_365 vccd1 vssd1 vccd1 vssd1 sky130_ef_sc_hd__decap_12
X_2550_ _0936_ _1000_ _1001_ _1007_ vssd1 vssd1 vccd1 vccd1 _1008_ sky130_fd_sc_hd__o211ai_4
X_2481_ _0713_ vssd1 vssd1 vccd1 vccd1 _0939_ sky130_fd_sc_hd__buf_4
X_4220_ _1051_ _1057_ net12 _1694_ _1695_ vssd1 vssd1 vccd1 vccd1 _2110_ sky130_fd_sc_hd__o2111a_1
X_4151_ net476 _2062_ _2075_ _2061_ vssd1 vssd1 vccd1 vccd1 _0534_ sky130_fd_sc_hd__o2bb2ai_1
X_3102_ net484 u_timer.count_reg\[18\] _1532_ _1535_ _0001_ vssd1 vssd1 vccd1 vccd1
+ _0017_ sky130_fd_sc_hd__a311oi_1
X_4082_ net174 vssd1 vssd1 vccd1 vccd1 _2037_ sky130_fd_sc_hd__clkbuf_1
X_3033_ _0707_ vssd1 vssd1 vccd1 vccd1 _1487_ sky130_fd_sc_hd__clkbuf_4
X_3935_ _1963_ vssd1 vssd1 vccd1 vccd1 _0430_ sky130_fd_sc_hd__clkbuf_1
XFILLER_0_58_373 vssd1 vssd1 vccd1 vccd1 sky130_fd_sc_hd__decap_8
XFILLER_0_85_181 vccd1 vssd1 vccd1 vssd1 sky130_ef_sc_hd__decap_12
XFILLER_0_73_321 vssd1 vssd1 vccd1 vccd1 sky130_fd_sc_hd__decap_8
XFILLER_0_18_248 vssd1 vssd1 vccd1 vccd1 sky130_fd_sc_hd__fill_1
X_3866_ net251 vssd1 vssd1 vccd1 vccd1 _1929_ sky130_fd_sc_hd__clkbuf_1
XFILLER_0_73_376 vssd1 vssd1 vccd1 vccd1 sky130_fd_sc_hd__decap_8
XFILLER_0_61_505 vssd1 vssd1 vccd1 vccd1 sky130_fd_sc_hd__decap_4
XFILLER_0_82_3 vccd1 vssd1 vccd1 vssd1 sky130_ef_sc_hd__decap_12
X_2817_ _0780_ _1222_ _1214_ vssd1 vssd1 vccd1 vccd1 _1275_ sky130_fd_sc_hd__or3b_4
X_3797_ _1336_ _1374_ _0783_ _1894_ vssd1 vssd1 vccd1 vccd1 _0361_ sky130_fd_sc_hd__a31o_1
X_2748_ _1205_ vssd1 vssd1 vccd1 vccd1 _1206_ sky130_fd_sc_hd__clkbuf_2
X_2679_ _0735_ _1085_ _1074_ _1079_ vssd1 vssd1 vccd1 vccd1 _1137_ sky130_fd_sc_hd__a31oi_1
X_4418_ clknet_leaf_27_clk _0229_ vssd1 vssd1 vccd1 vccd1 u_core.u_regfile.rf\[29\]\[22\]
+ sky130_fd_sc_hd__dfxtp_1
X_4349_ clknet_leaf_32_clk _0160_ vssd1 vssd1 vccd1 vccd1 u_core.u_regfile.rf\[5\]\[17\]
+ sky130_fd_sc_hd__dfxtp_1
XTAP_181 vssd1 vccd1 sky130_fd_sc_hd__tapvpwrvgnd_1
XTAP_192 vssd1 vccd1 sky130_fd_sc_hd__tapvpwrvgnd_1
XFILLER_0_68_126 vssd1 vssd1 vccd1 vccd1 sky130_fd_sc_hd__fill_2
XFILLER_0_64_321 vssd1 vssd1 vccd1 vccd1 sky130_fd_sc_hd__fill_2
XFILLER_0_64_376 vssd1 vssd1 vccd1 vccd1 sky130_fd_sc_hd__fill_1
XFILLER_0_17_281 vssd1 vssd1 vccd1 vccd1 sky130_fd_sc_hd__fill_2
XFILLER_0_32_273 vssd1 vssd1 vccd1 vccd1 sky130_fd_sc_hd__decap_8
XFILLER_0_74_29 vccd1 vssd1 vccd1 vssd1 sky130_ef_sc_hd__decap_12
X_3720_ _1852_ vssd1 vssd1 vccd1 vccd1 _0326_ sky130_fd_sc_hd__clkbuf_1
Xclkbuf_leaf_40_clk clknet_2_1__leaf_clk vssd1 vssd1 vccd1 vccd1 clknet_leaf_40_clk
+ sky130_fd_sc_hd__clkbuf_16
XFILLER_0_55_376 vccd1 vssd1 vccd1 vssd1 sky130_ef_sc_hd__decap_12
X_3651_ net287 vssd1 vssd1 vccd1 vccd1 _1818_ sky130_fd_sc_hd__clkbuf_1
X_3582_ _1791_ _1792_ _1790_ net61 vssd1 vssd1 vccd1 vccd1 _0248_ sky130_fd_sc_hd__o31a_1
X_2602_ _0922_ _0740_ u_core.u_regfile.rf\[28\]\[2\] vssd1 vssd1 vccd1 vccd1 _1060_
+ sky130_fd_sc_hd__o21ai_1
X_2533_ _0757_ net20 _0990_ vssd1 vssd1 vccd1 vccd1 _0991_ sky130_fd_sc_hd__o21bai_1
X_2464_ _0729_ vssd1 vssd1 vccd1 vccd1 _0922_ sky130_fd_sc_hd__buf_4
XFILLER_0_48_41 vssd1 vssd1 vccd1 vccd1 sky130_fd_sc_hd__decap_4
X_2395_ u_core.u_regfile.rf\[29\]\[14\] u_core.u_regfile.rf\[31\]\[14\] _0721_ vssd1
+ vssd1 vccd1 vccd1 _0853_ sky130_fd_sc_hd__mux2_1
XFILLER_0_48_85 vssd1 vssd1 vccd1 vccd1 sky130_fd_sc_hd__fill_2
X_4203_ _2101_ vssd1 vssd1 vccd1 vccd1 _0560_ sky130_fd_sc_hd__clkbuf_1
X_4134_ _1688_ _1689_ vssd1 vssd1 vccd1 vccd1 _2065_ sky130_fd_sc_hd__or2_1
X_4065_ _2028_ vssd1 vssd1 vccd1 vccd1 _0495_ sky130_fd_sc_hd__clkbuf_1
Xwire11 _1685_ vssd1 vssd1 vccd1 vccd1 net11 sky130_fd_sc_hd__buf_1
X_3016_ _1299_ _1371_ _1387_ vssd1 vssd1 vccd1 vccd1 _1474_ sky130_fd_sc_hd__o21ai_1
XFILLER_0_65_129 vssd1 vssd1 vccd1 vccd1 sky130_fd_sc_hd__fill_2
XFILLER_0_80_83 vssd1 vssd1 vccd1 vccd1 sky130_fd_sc_hd__fill_1
X_3918_ net430 vssd1 vssd1 vccd1 vccd1 _1955_ sky130_fd_sc_hd__clkbuf_1
Xclkbuf_leaf_31_clk clknet_2_1__leaf_clk vssd1 vssd1 vccd1 vccd1 clknet_leaf_31_clk
+ sky130_fd_sc_hd__clkbuf_16
XFILLER_0_73_184 vssd1 vssd1 vccd1 vccd1 sky130_fd_sc_hd__fill_2
X_3849_ _1920_ vssd1 vssd1 vccd1 vccd1 _0387_ sky130_fd_sc_hd__clkbuf_1
XFILLER_0_61_335 vssd1 vssd1 vccd1 vccd1 sky130_fd_sc_hd__fill_1
XFILLER_0_61_357 vssd1 vssd1 vccd1 vccd1 sky130_fd_sc_hd__fill_2
XFILLER_0_69_424 vssd1 vssd1 vccd1 vccd1 sky130_fd_sc_hd__decap_4
XFILLER_0_37_332 vssd1 vssd1 vccd1 vccd1 sky130_fd_sc_hd__decap_4
Xclkbuf_leaf_22_clk clknet_2_3__leaf_clk vssd1 vssd1 vccd1 vccd1 clknet_leaf_22_clk
+ sky130_fd_sc_hd__clkbuf_16
XFILLER_0_25_505 vssd1 vssd1 vccd1 vccd1 sky130_fd_sc_hd__decap_4
XTAP_917 vssd1 vccd1 sky130_fd_sc_hd__tapvpwrvgnd_1
XTAP_906 vssd1 vccd1 sky130_fd_sc_hd__tapvpwrvgnd_1
XFILLER_0_20_265 vssd1 vssd1 vccd1 vccd1 sky130_fd_sc_hd__decap_6
XTAP_939 vssd1 vccd1 sky130_fd_sc_hd__tapvpwrvgnd_1
XTAP_928 vssd1 vccd1 sky130_fd_sc_hd__tapvpwrvgnd_1
X_2180_ net249 vssd1 vssd1 vccd1 vccd1 _0639_ sky130_fd_sc_hd__inv_2
XFILLER_0_34_54 vssd1 vssd1 vccd1 vccd1 sky130_fd_sc_hd__fill_2
XFILLER_0_75_438 vssd1 vssd1 vccd1 vccd1 sky130_fd_sc_hd__fill_1
XFILLER_0_75_449 vssd1 vssd1 vccd1 vccd1 sky130_fd_sc_hd__decap_8
X_4752_ clknet_leaf_22_clk _0016_ net31 vssd1 vssd1 vccd1 vccd1 u_timer.count_reg\[18\]
+ sky130_fd_sc_hd__dfrtp_2
Xclkbuf_leaf_13_clk clknet_2_2__leaf_clk vssd1 vssd1 vccd1 vccd1 clknet_leaf_13_clk
+ sky130_fd_sc_hd__clkbuf_16
XFILLER_0_28_343 vssd1 vssd1 vccd1 vccd1 sky130_fd_sc_hd__decap_4
X_3703_ net314 vssd1 vssd1 vccd1 vccd1 _1844_ sky130_fd_sc_hd__clkbuf_1
XFILLER_0_43_313 vssd1 vssd1 vccd1 vccd1 sky130_fd_sc_hd__fill_2
XFILLER_0_43_324 vssd1 vssd1 vccd1 vccd1 sky130_fd_sc_hd__fill_1
XFILLER_0_50_75 vssd1 vssd1 vccd1 vccd1 sky130_fd_sc_hd__decap_8
X_4683_ clknet_leaf_25_clk _0484_ vssd1 vssd1 vccd1 vccd1 u_core.u_regfile.rf\[24\]\[21\]
+ sky130_fd_sc_hd__dfxtp_1
X_3634_ _1809_ vssd1 vssd1 vccd1 vccd1 _0283_ sky130_fd_sc_hd__clkbuf_1
XFILLER_0_70_165 vccd1 vssd1 vccd1 vssd1 sky130_ef_sc_hd__decap_12
XFILLER_0_11_232 vssd1 vssd1 vccd1 vccd1 sky130_fd_sc_hd__fill_1
X_3565_ _1787_ vssd1 vssd1 vccd1 vccd1 _0236_ sky130_fd_sc_hd__clkbuf_1
X_2516_ u_core.u_regfile.rf\[31\]\[10\] _0895_ _0746_ _0715_ _0973_ vssd1 vssd1 vccd1
+ vccd1 _0974_ sky130_fd_sc_hd__o221ai_4
X_3496_ _0800_ _1741_ _1752_ vssd1 vssd1 vccd1 vccd1 _0202_ sky130_fd_sc_hd__o21ai_1
X_2447_ u_core.u_regfile.rf\[5\]\[13\] _0733_ _0904_ _0770_ _0773_ vssd1 vssd1 vccd1
+ vccd1 _0905_ sky130_fd_sc_hd__o32a_1
XFILLER_0_45_3 vccd1 vssd1 vccd1 vssd1 sky130_ef_sc_hd__decap_12
X_2378_ u_core.u_regfile.rf\[4\]\[24\] _0751_ _0834_ _0835_ vssd1 vssd1 vccd1 vccd1
+ _0836_ sky130_fd_sc_hd__o22ai_2
X_4117_ _2054_ vssd1 vssd1 vccd1 vccd1 _0521_ sky130_fd_sc_hd__clkbuf_1
XFILLER_0_78_221 vssd1 vssd1 vccd1 vccd1 sky130_fd_sc_hd__decap_8
X_4048_ net228 vssd1 vssd1 vccd1 vccd1 _2020_ sky130_fd_sc_hd__clkbuf_1
XFILLER_0_19_354 vssd1 vssd1 vccd1 vccd1 sky130_fd_sc_hd__fill_1
XFILLER_0_74_471 vssd1 vssd1 vccd1 vccd1 sky130_fd_sc_hd__decap_4
XFILLER_0_34_324 vssd1 vssd1 vccd1 vccd1 sky130_fd_sc_hd__decap_4
XFILLER_0_46_195 vssd1 vssd1 vccd1 vccd1 sky130_fd_sc_hd__fill_1
Xhold9 u_core.u_regfile.rf\[28\]\[12\] vssd1 vssd1 vccd1 vccd1 net42 sky130_fd_sc_hd__dlygate4sd3_1
XFILLER_0_69_243 vccd1 vssd1 vccd1 vssd1 sky130_ef_sc_hd__decap_12
XFILLER_0_37_151 vssd1 vssd1 vccd1 vccd1 sky130_fd_sc_hd__fill_1
XFILLER_0_13_508 vssd1 vssd1 vccd1 vccd1 sky130_fd_sc_hd__fill_2
XFILLER_0_52_132 vssd1 vssd1 vccd1 vccd1 sky130_fd_sc_hd__decap_4
Xhold409 u_core.u_regfile.rf\[4\]\[21\] vssd1 vssd1 vccd1 vccd1 net442 sky130_fd_sc_hd__dlygate4sd3_1
XFILLER_0_52_165 vssd1 vssd1 vccd1 vccd1 sky130_fd_sc_hd__fill_2
XFILLER_0_52_187 vssd1 vssd1 vccd1 vccd1 sky130_fd_sc_hd__decap_3
X_3350_ _1484_ vssd1 vssd1 vccd1 vccd1 _1666_ sky130_fd_sc_hd__clkbuf_4
XFILLER_0_29_32 vssd1 vssd1 vccd1 vccd1 sky130_fd_sc_hd__fill_1
X_2301_ _0758_ vssd1 vssd1 vccd1 vccd1 _0759_ sky130_fd_sc_hd__clkbuf_4
XTAP_703 vssd1 vccd1 sky130_fd_sc_hd__tapvpwrvgnd_1
XTAP_714 vssd1 vccd1 sky130_fd_sc_hd__tapvpwrvgnd_1
XTAP_725 vssd1 vccd1 sky130_fd_sc_hd__tapvpwrvgnd_1
X_3281_ _1629_ _1630_ _1631_ net101 vssd1 vssd1 vccd1 vccd1 _0108_ sky130_fd_sc_hd__o31a_1
XTAP_736 vssd1 vccd1 sky130_fd_sc_hd__tapvpwrvgnd_1
XTAP_747 vssd1 vccd1 sky130_fd_sc_hd__tapvpwrvgnd_1
XTAP_758 vssd1 vccd1 sky130_fd_sc_hd__tapvpwrvgnd_1
X_2232_ u_imem.addr\[3\] _0688_ vssd1 vssd1 vccd1 vccd1 _0690_ sky130_fd_sc_hd__and2b_1
Xclkbuf_leaf_2_clk clknet_2_0__leaf_clk vssd1 vssd1 vccd1 vccd1 clknet_leaf_2_clk
+ sky130_fd_sc_hd__clkbuf_16
XTAP_769 vssd1 vccd1 sky130_fd_sc_hd__tapvpwrvgnd_1
X_2163_ _0620_ u_timer.count_reg\[10\] _0621_ u_timer.count_reg\[11\] vssd1 vssd1
+ vccd1 vccd1 _0622_ sky130_fd_sc_hd__a22oi_1
XFILLER_0_31_9 vssd1 vssd1 vccd1 vccd1 sky130_fd_sc_hd__fill_1
XFILLER_0_45_53 vssd1 vssd1 vccd1 vccd1 sky130_fd_sc_hd__decap_3
X_4804_ clknet_leaf_10_clk _0572_ net21 vssd1 vssd1 vccd1 vccd1 u_audio.sample_reg\[5\]
+ sky130_fd_sc_hd__dfrtp_1
XFILLER_0_63_408 vssd1 vssd1 vccd1 vccd1 sky130_fd_sc_hd__decap_6
X_4735_ clknet_leaf_12_clk _0018_ net26 vssd1 vssd1 vccd1 vccd1 u_timer.count_reg\[1\]
+ sky130_fd_sc_hd__dfrtp_4
X_2996_ _1003_ _1446_ _0919_ vssd1 vssd1 vccd1 vccd1 _1454_ sky130_fd_sc_hd__a21bo_1
XFILLER_0_31_316 vssd1 vssd1 vccd1 vccd1 sky130_fd_sc_hd__decap_3
X_4666_ clknet_leaf_25_clk _0467_ vssd1 vssd1 vccd1 vccd1 u_core.u_regfile.rf\[24\]\[4\]
+ sky130_fd_sc_hd__dfxtp_1
X_4597_ clknet_leaf_26_clk _0398_ vssd1 vssd1 vccd1 vccd1 u_core.u_regfile.rf\[27\]\[31\]
+ sky130_fd_sc_hd__dfxtp_1
X_3617_ net354 vssd1 vssd1 vccd1 vccd1 _1801_ sky130_fd_sc_hd__clkbuf_1
X_3548_ net390 vssd1 vssd1 vccd1 vccd1 _1779_ sky130_fd_sc_hd__clkbuf_1
X_3479_ _1731_ _1725_ _1739_ _1726_ _0666_ vssd1 vssd1 vccd1 vccd1 _1743_ sky130_fd_sc_hd__a41o_1
XFILLER_0_39_449 vccd1 vssd1 vccd1 vssd1 sky130_ef_sc_hd__decap_12
XFILLER_0_82_29 vccd1 vssd1 vccd1 vssd1 sky130_ef_sc_hd__decap_12
X_2850_ u_core.u_regfile.rf\[31\]\[30\] _0728_ _1303_ _1307_ net19 vssd1 vssd1 vccd1
+ vccd1 _1308_ sky130_fd_sc_hd__o221ai_4
XFILLER_0_72_227 vssd1 vssd1 vccd1 vccd1 sky130_fd_sc_hd__decap_4
XFILLER_0_72_205 vssd1 vssd1 vccd1 vccd1 sky130_fd_sc_hd__fill_2
XFILLER_0_5_505 vssd1 vssd1 vccd1 vccd1 sky130_fd_sc_hd__decap_4
XFILLER_0_31_77 vssd1 vssd1 vccd1 vccd1 sky130_fd_sc_hd__decap_3
X_2781_ u_core.u_regfile.rf\[31\]\[23\] _0727_ _1133_ _0759_ vssd1 vssd1 vccd1 vccd1
+ _1239_ sky130_fd_sc_hd__a2bb2o_1
XFILLER_0_65_290 vssd1 vssd1 vccd1 vccd1 sky130_fd_sc_hd__decap_6
XFILLER_0_53_474 vccd1 vssd1 vccd1 vssd1 sky130_ef_sc_hd__decap_12
X_4520_ clknet_leaf_22_clk _0321_ vssd1 vssd1 vccd1 vccd1 u_core.u_regfile.rf\[2\]\[18\]
+ sky130_fd_sc_hd__dfxtp_1
X_4451_ clknet_leaf_0_clk _0252_ vssd1 vssd1 vccd1 vccd1 u_core.u_regfile.rf\[7\]\[13\]
+ sky130_fd_sc_hd__dfxtp_1
Xhold217 u_core.u_regfile.rf\[27\]\[24\] vssd1 vssd1 vccd1 vccd1 net250 sky130_fd_sc_hd__dlygate4sd3_1
Xhold206 u_core.u_regfile.rf\[30\]\[13\] vssd1 vssd1 vccd1 vccd1 net239 sky130_fd_sc_hd__dlygate4sd3_1
Xhold228 u_core.u_regfile.rf\[27\]\[1\] vssd1 vssd1 vccd1 vccd1 net261 sky130_fd_sc_hd__dlygate4sd3_1
XFILLER_0_0_221 vssd1 vssd1 vccd1 vccd1 sky130_fd_sc_hd__decap_3
X_3402_ net11 vssd1 vssd1 vccd1 vccd1 _1686_ sky130_fd_sc_hd__clkbuf_4
Xhold239 u_core.u_regfile.rf\[26\]\[24\] vssd1 vssd1 vccd1 vccd1 net272 sky130_fd_sc_hd__dlygate4sd3_1
XTAP_500 vssd1 vccd1 sky130_fd_sc_hd__tapvpwrvgnd_1
XFILLER_0_40_179 vssd1 vssd1 vccd1 vccd1 sky130_fd_sc_hd__decap_6
X_4382_ clknet_leaf_19_clk _0193_ net27 vssd1 vssd1 vccd1 vccd1 u_timer.threshold_reg\[18\]
+ sky130_fd_sc_hd__dfrtp_1
X_3333_ _1657_ vssd1 vssd1 vccd1 vccd1 _0134_ sky130_fd_sc_hd__clkbuf_1
XFILLER_0_0_265 vccd1 vssd1 vccd1 vssd1 sky130_ef_sc_hd__decap_12
XTAP_511 vssd1 vccd1 sky130_fd_sc_hd__tapvpwrvgnd_1
XTAP_522 vssd1 vccd1 sky130_fd_sc_hd__tapvpwrvgnd_1
XTAP_533 vssd1 vccd1 sky130_fd_sc_hd__tapvpwrvgnd_1
X_3264_ _1626_ _1627_ _1628_ net66 vssd1 vssd1 vccd1 vccd1 _0094_ sky130_fd_sc_hd__o31a_1
XTAP_544 vssd1 vccd1 sky130_fd_sc_hd__tapvpwrvgnd_1
XTAP_555 vssd1 vccd1 sky130_fd_sc_hd__tapvpwrvgnd_1
XTAP_566 vssd1 vccd1 sky130_fd_sc_hd__tapvpwrvgnd_1
XFILLER_0_56_41 vccd1 vssd1 vccd1 vssd1 sky130_ef_sc_hd__decap_12
X_2215_ u_timer.count_reg\[19\] vssd1 vssd1 vccd1 vccd1 _0674_ sky130_fd_sc_hd__inv_2
XTAP_577 vssd1 vccd1 sky130_fd_sc_hd__tapvpwrvgnd_1
XTAP_588 vssd1 vccd1 sky130_fd_sc_hd__tapvpwrvgnd_1
XTAP_599 vssd1 vccd1 sky130_fd_sc_hd__tapvpwrvgnd_1
X_3195_ net479 vssd1 vssd1 vccd1 vccd1 _1599_ sky130_fd_sc_hd__clkbuf_1
X_2146_ u_timer.count_reg\[18\] vssd1 vssd1 vccd1 vccd1 _0605_ sky130_fd_sc_hd__inv_2
XFILLER_0_36_408 vccd1 vssd1 vccd1 vssd1 sky130_ef_sc_hd__decap_12
XFILLER_0_8_332 vssd1 vssd1 vccd1 vccd1 sky130_fd_sc_hd__decap_6
XFILLER_0_29_482 vssd1 vssd1 vccd1 vccd1 sky130_fd_sc_hd__decap_4
XFILLER_0_63_238 vccd1 vssd1 vccd1 vssd1 sky130_ef_sc_hd__decap_12
XFILLER_0_8_365 vccd1 vssd1 vccd1 vssd1 sky130_ef_sc_hd__decap_12
X_2979_ _1086_ _1087_ _1101_ _1435_ vssd1 vssd1 vccd1 vccd1 _1437_ sky130_fd_sc_hd__nand4_1
X_4718_ clknet_leaf_49_clk _0519_ vssd1 vssd1 vccd1 vccd1 u_core.u_regfile.rf\[25\]\[24\]
+ sky130_fd_sc_hd__dfxtp_1
X_4649_ clknet_leaf_26_clk _0450_ vssd1 vssd1 vccd1 vccd1 u_core.u_regfile.rf\[26\]\[19\]
+ sky130_fd_sc_hd__dfxtp_1
XFILLER_0_12_360 vssd1 vssd1 vccd1 vccd1 sky130_fd_sc_hd__fill_1
XFILLER_0_79_360 vccd1 vssd1 vccd1 vssd1 sky130_ef_sc_hd__decap_12
XFILLER_0_79_393 vccd1 vssd1 vccd1 vssd1 sky130_ef_sc_hd__decap_12
XFILLER_0_39_257 vccd1 vssd1 vccd1 vssd1 sky130_ef_sc_hd__decap_12
XFILLER_0_35_452 vssd1 vssd1 vccd1 vccd1 sky130_fd_sc_hd__fill_2
XFILLER_0_50_499 vssd1 vssd1 vccd1 vccd1 sky130_fd_sc_hd__decap_3
XFILLER_0_26_11 vssd1 vssd1 vccd1 vccd1 sky130_fd_sc_hd__fill_1
X_3951_ _1971_ vssd1 vssd1 vccd1 vccd1 _0438_ sky130_fd_sc_hd__clkbuf_1
X_2902_ _1337_ _1338_ _1345_ net14 _1359_ vssd1 vssd1 vccd1 vccd1 _1360_ sky130_fd_sc_hd__o221ai_4
X_3882_ net431 vssd1 vssd1 vccd1 vccd1 _1937_ sky130_fd_sc_hd__clkbuf_1
X_2833_ _1288_ _1289_ _1290_ vssd1 vssd1 vccd1 vccd1 _1291_ sky130_fd_sc_hd__a21oi_2
XFILLER_0_5_335 vssd1 vssd1 vccd1 vccd1 sky130_fd_sc_hd__fill_1
XFILLER_0_26_474 vssd1 vssd1 vccd1 vccd1 sky130_fd_sc_hd__fill_2
X_2764_ u_core.u_regfile.rf\[31\]\[20\] _0727_ _0746_ _0715_ _1220_ vssd1 vssd1 vccd1
+ vccd1 _1222_ sky130_fd_sc_hd__o221ai_4
XFILLER_0_13_113 vssd1 vssd1 vccd1 vccd1 sky130_fd_sc_hd__decap_3
XFILLER_0_26_485 vssd1 vssd1 vccd1 vccd1 sky130_fd_sc_hd__fill_2
XFILLER_0_53_293 vssd1 vssd1 vccd1 vccd1 sky130_fd_sc_hd__decap_6
X_4503_ clknet_leaf_24_clk _0304_ vssd1 vssd1 vccd1 vccd1 u_core.u_regfile.rf\[2\]\[1\]
+ sky130_fd_sc_hd__dfxtp_1
X_2695_ _0913_ u_core.u_regfile.rf\[1\]\[19\] _0874_ _0914_ vssd1 vssd1 vccd1 vccd1
+ _1153_ sky130_fd_sc_hd__a31o_1
X_4434_ clknet_leaf_9_clk _0044_ net22 vssd1 vssd1 vccd1 vccd1 u_audio.counter\[5\]
+ sky130_fd_sc_hd__dfrtp_1
X_4365_ clknet_leaf_12_clk _0176_ net26 vssd1 vssd1 vccd1 vccd1 u_timer.threshold_reg\[1\]
+ sky130_fd_sc_hd__dfrtp_1
XTAP_341 vssd1 vccd1 sky130_fd_sc_hd__tapvpwrvgnd_1
XTAP_330 vssd1 vccd1 sky130_fd_sc_hd__tapvpwrvgnd_1
X_3316_ net481 vssd1 vssd1 vccd1 vccd1 _1649_ sky130_fd_sc_hd__clkbuf_1
XTAP_352 vssd1 vccd1 sky130_fd_sc_hd__tapvpwrvgnd_1
XTAP_363 vssd1 vccd1 sky130_fd_sc_hd__tapvpwrvgnd_1
XTAP_374 vssd1 vccd1 sky130_fd_sc_hd__tapvpwrvgnd_1
XTAP_385 vssd1 vccd1 sky130_fd_sc_hd__tapvpwrvgnd_1
X_4296_ clknet_leaf_2_clk _0107_ vssd1 vssd1 vccd1 vccd1 u_core.u_regfile.rf\[6\]\[28\]
+ sky130_fd_sc_hd__dfxtp_1
X_3247_ _1623_ _1624_ _1625_ net47 vssd1 vssd1 vccd1 vccd1 _0080_ sky130_fd_sc_hd__o31a_1
XTAP_396 vssd1 vccd1 sky130_fd_sc_hd__tapvpwrvgnd_1
X_3178_ net508 _1589_ vssd1 vssd1 vccd1 vccd1 _0046_ sky130_fd_sc_hd__xor2_1
X_2129_ u_timer.threshold_reg\[27\] vssd1 vssd1 vccd1 vccd1 _0588_ sky130_fd_sc_hd__inv_2
XPHY_36 vssd1 vssd1 vccd1 vccd1 sky130_fd_sc_hd__decap_3
XPHY_25 vssd1 vssd1 vccd1 vccd1 sky130_fd_sc_hd__decap_3
XPHY_14 vssd1 vssd1 vccd1 vccd1 sky130_fd_sc_hd__decap_3
XPHY_47 vssd1 vssd1 vccd1 vccd1 sky130_fd_sc_hd__decap_3
XPHY_58 vssd1 vssd1 vccd1 vccd1 sky130_fd_sc_hd__decap_3
XPHY_69 vssd1 vssd1 vccd1 vccd1 sky130_fd_sc_hd__decap_3
XFILLER_0_36_216 vssd1 vssd1 vccd1 vccd1 sky130_fd_sc_hd__decap_8
XFILLER_0_8_195 vssd1 vssd1 vccd1 vccd1 sky130_fd_sc_hd__fill_1
XFILLER_0_32_411 vssd1 vssd1 vccd1 vccd1 sky130_fd_sc_hd__decap_4
XFILLER_0_32_477 vssd1 vssd1 vccd1 vccd1 sky130_fd_sc_hd__decap_4
XFILLER_0_67_363 vssd1 vssd1 vccd1 vccd1 sky130_fd_sc_hd__fill_1
XFILLER_0_82_377 vccd1 vssd1 vccd1 vssd1 sky130_ef_sc_hd__decap_12
XFILLER_0_12_79 vssd1 vssd1 vccd1 vccd1 sky130_fd_sc_hd__fill_2
XFILLER_0_35_271 vssd1 vssd1 vccd1 vccd1 sky130_fd_sc_hd__fill_2
X_2480_ _0753_ vssd1 vssd1 vccd1 vccd1 _0938_ sky130_fd_sc_hd__buf_4
XFILLER_0_10_138 vssd1 vssd1 vccd1 vccd1 sky130_fd_sc_hd__fill_2
X_4150_ _1136_ _1686_ _1737_ vssd1 vssd1 vccd1 vccd1 _2075_ sky130_fd_sc_hd__nand3b_1
X_3101_ _0605_ _0606_ _0661_ _1528_ _0674_ vssd1 vssd1 vccd1 vccd1 _1535_ sky130_fd_sc_hd__o41a_1
X_4081_ _2036_ vssd1 vssd1 vccd1 vccd1 _0503_ sky130_fd_sc_hd__clkbuf_1
X_3032_ _0720_ vssd1 vssd1 vccd1 vccd1 _1486_ sky130_fd_sc_hd__clkbuf_4
XFILLER_0_77_105 vssd1 vssd1 vccd1 vccd1 sky130_fd_sc_hd__decap_4
XFILLER_0_77_138 vssd1 vssd1 vccd1 vccd1 sky130_fd_sc_hd__fill_1
X_3934_ net408 vssd1 vssd1 vccd1 vccd1 _1963_ sky130_fd_sc_hd__clkbuf_1
XFILLER_0_85_193 vssd1 vssd1 vccd1 vccd1 sky130_fd_sc_hd__decap_3
X_3865_ _1928_ vssd1 vssd1 vccd1 vccd1 _0395_ sky130_fd_sc_hd__clkbuf_1
XFILLER_0_5_110 vssd1 vssd1 vccd1 vccd1 sky130_fd_sc_hd__fill_2
X_2816_ _1008_ _1152_ _1273_ vssd1 vssd1 vccd1 vccd1 _1274_ sky130_fd_sc_hd__o21bai_2
XFILLER_0_73_399 vssd1 vssd1 vccd1 vccd1 sky130_fd_sc_hd__fill_1
X_3796_ _1484_ _0737_ net519 vssd1 vssd1 vccd1 vccd1 _1894_ sky130_fd_sc_hd__o21a_1
XFILLER_0_5_176 vssd1 vssd1 vccd1 vccd1 sky130_fd_sc_hd__decap_4
X_2747_ _0734_ _1198_ _1203_ _1204_ vssd1 vssd1 vccd1 vccd1 _1205_ sky130_fd_sc_hd__and4_1
XFILLER_0_75_3 vccd1 vssd1 vccd1 vssd1 sky130_ef_sc_hd__decap_12
XFILLER_0_41_274 vssd1 vssd1 vccd1 vccd1 sky130_fd_sc_hd__fill_2
X_2678_ _1134_ _1135_ vssd1 vssd1 vccd1 vccd1 _1136_ sky130_fd_sc_hd__or2_1
XFILLER_0_78_83 vssd1 vssd1 vccd1 vccd1 sky130_fd_sc_hd__fill_1
X_4417_ clknet_leaf_28_clk _0228_ vssd1 vssd1 vccd1 vccd1 u_core.u_regfile.rf\[29\]\[21\]
+ sky130_fd_sc_hd__dfxtp_1
XFILLER_0_1_393 vccd1 vssd1 vccd1 vssd1 sky130_ef_sc_hd__decap_12
X_4348_ clknet_leaf_30_clk _0159_ vssd1 vssd1 vccd1 vccd1 u_core.u_regfile.rf\[5\]\[16\]
+ sky130_fd_sc_hd__dfxtp_1
X_4279_ clknet_leaf_47_clk _0090_ vssd1 vssd1 vccd1 vccd1 u_core.u_regfile.rf\[6\]\[11\]
+ sky130_fd_sc_hd__dfxtp_1
XTAP_182 vssd1 vccd1 sky130_fd_sc_hd__tapvpwrvgnd_1
XTAP_193 vssd1 vccd1 sky130_fd_sc_hd__tapvpwrvgnd_1
XFILLER_0_49_330 vssd1 vssd1 vccd1 vccd1 sky130_fd_sc_hd__decap_6
XFILLER_0_76_160 vssd1 vssd1 vccd1 vccd1 sky130_fd_sc_hd__decap_3
XFILLER_0_49_374 vssd1 vssd1 vccd1 vccd1 sky130_fd_sc_hd__fill_2
XFILLER_0_49_385 vssd1 vssd1 vccd1 vccd1 sky130_fd_sc_hd__fill_2
XFILLER_0_17_271 vssd1 vssd1 vccd1 vccd1 sky130_fd_sc_hd__fill_1
XFILLER_0_64_388 vssd1 vssd1 vccd1 vccd1 sky130_fd_sc_hd__decap_4
XFILLER_0_82_141 vssd1 vssd1 vccd1 vccd1 sky130_fd_sc_hd__fill_1
X_3650_ _1817_ vssd1 vssd1 vccd1 vccd1 _0291_ sky130_fd_sc_hd__clkbuf_1
X_3581_ _1791_ _1792_ _1790_ net84 vssd1 vssd1 vccd1 vccd1 _0247_ sky130_fd_sc_hd__o31a_1
X_2601_ _0685_ u_core.u_regfile.rf\[29\]\[2\] _1058_ vssd1 vssd1 vccd1 vccd1 _1059_
+ sky130_fd_sc_hd__a21oi_1
X_2532_ u_core.u_regfile.rf\[6\]\[11\] vssd1 vssd1 vccd1 vccd1 _0990_ sky130_fd_sc_hd__inv_2
XFILLER_0_2_157 vccd1 vssd1 vccd1 vssd1 sky130_ef_sc_hd__decap_12
X_2463_ _0860_ u_core.u_regfile.rf\[7\]\[15\] _0861_ vssd1 vssd1 vccd1 vccd1 _0921_
+ sky130_fd_sc_hd__nand3_1
X_4202_ net238 vssd1 vssd1 vccd1 vccd1 _2101_ sky130_fd_sc_hd__clkbuf_1
X_2394_ _0807_ _0851_ vssd1 vssd1 vccd1 vccd1 _0852_ sky130_fd_sc_hd__nand2_1
X_4133_ net560 _2062_ _2064_ _2061_ vssd1 vssd1 vccd1 vccd1 _0527_ sky130_fd_sc_hd__o2bb2ai_1
X_4064_ net165 vssd1 vssd1 vccd1 vccd1 _2028_ sky130_fd_sc_hd__clkbuf_1
XFILLER_0_3_55 vssd1 vssd1 vccd1 vccd1 sky130_fd_sc_hd__fill_1
XFILLER_0_3_77 vssd1 vssd1 vccd1 vccd1 sky130_fd_sc_hd__fill_1
X_3015_ _1417_ _1419_ _1467_ _1472_ vssd1 vssd1 vccd1 vccd1 _1473_ sky130_fd_sc_hd__nor4_1
XFILLER_0_64_41 vccd1 vssd1 vccd1 vssd1 sky130_ef_sc_hd__decap_12
XFILLER_0_64_85 vssd1 vssd1 vccd1 vccd1 sky130_fd_sc_hd__decap_8
XFILLER_0_19_503 vssd1 vssd1 vccd1 vccd1 sky130_fd_sc_hd__fill_1
XFILLER_0_46_300 vssd1 vssd1 vccd1 vccd1 sky130_fd_sc_hd__decap_8
X_3917_ _1954_ vssd1 vssd1 vccd1 vccd1 _0421_ sky130_fd_sc_hd__clkbuf_1
XFILLER_0_46_344 vccd1 vssd1 vccd1 vssd1 sky130_ef_sc_hd__decap_12
X_3848_ net275 vssd1 vssd1 vccd1 vccd1 _1920_ sky130_fd_sc_hd__clkbuf_1
XFILLER_0_6_474 vssd1 vssd1 vccd1 vccd1 sky130_fd_sc_hd__fill_2
X_3779_ _1397_ _1396_ _1875_ _1885_ vssd1 vssd1 vccd1 vccd1 _0352_ sky130_fd_sc_hd__a31o_1
XFILLER_0_14_263 vssd1 vssd1 vccd1 vccd1 sky130_fd_sc_hd__fill_2
XFILLER_0_77_480 vccd1 vssd1 vccd1 vssd1 sky130_ef_sc_hd__decap_12
XFILLER_0_37_311 vssd1 vssd1 vccd1 vccd1 sky130_fd_sc_hd__fill_1
XFILLER_0_37_344 vssd1 vssd1 vccd1 vccd1 sky130_fd_sc_hd__fill_1
XFILLER_0_64_141 vssd1 vssd1 vccd1 vccd1 sky130_fd_sc_hd__decap_6
XTAP_907 vssd1 vccd1 sky130_fd_sc_hd__tapvpwrvgnd_1
XFILLER_0_85_29 vssd1 vssd1 vccd1 vccd1 sky130_fd_sc_hd__decap_8
XTAP_929 vssd1 vccd1 sky130_fd_sc_hd__tapvpwrvgnd_1
XTAP_918 vssd1 vccd1 sky130_fd_sc_hd__tapvpwrvgnd_1
XFILLER_0_83_461 vccd1 vssd1 vccd1 vssd1 sky130_ef_sc_hd__decap_12
X_4751_ clknet_leaf_21_clk _0015_ net31 vssd1 vssd1 vccd1 vccd1 u_timer.count_reg\[17\]
+ sky130_fd_sc_hd__dfrtp_1
X_3702_ _1843_ vssd1 vssd1 vccd1 vccd1 _0317_ sky130_fd_sc_hd__clkbuf_1
X_4682_ clknet_leaf_36_clk _0483_ vssd1 vssd1 vccd1 vccd1 u_core.u_regfile.rf\[24\]\[20\]
+ sky130_fd_sc_hd__dfxtp_1
XFILLER_0_55_174 vssd1 vssd1 vccd1 vccd1 sky130_fd_sc_hd__fill_2
X_3633_ net152 vssd1 vssd1 vccd1 vccd1 _1809_ sky130_fd_sc_hd__clkbuf_1
XFILLER_0_31_509 vssd1 vssd1 vccd1 vccd1 sky130_fd_sc_hd__fill_1
XFILLER_0_70_177 vssd1 vssd1 vccd1 vccd1 sky130_fd_sc_hd__decap_4
X_3564_ net375 vssd1 vssd1 vccd1 vccd1 _1787_ sky130_fd_sc_hd__clkbuf_1
X_2515_ _0812_ _0970_ _0971_ _0972_ vssd1 vssd1 vccd1 vccd1 _0973_ sky130_fd_sc_hd__a31o_1
X_3495_ _1683_ _1413_ _1739_ _1480_ _0588_ vssd1 vssd1 vccd1 vccd1 _1752_ sky130_fd_sc_hd__a41o_1
X_2446_ _0903_ vssd1 vssd1 vccd1 vccd1 _0904_ sky130_fd_sc_hd__buf_4
XFILLER_0_75_51 vssd1 vssd1 vccd1 vccd1 sky130_fd_sc_hd__decap_4
X_2377_ _0803_ _0754_ u_core.u_regfile.rf\[7\]\[24\] _0756_ vssd1 vssd1 vccd1 vccd1
+ _0835_ sky130_fd_sc_hd__a31o_1
XFILLER_0_38_3 vccd1 vssd1 vccd1 vssd1 sky130_ef_sc_hd__decap_12
X_4116_ net292 vssd1 vssd1 vccd1 vccd1 _2054_ sky130_fd_sc_hd__clkbuf_1
X_4047_ _2019_ vssd1 vssd1 vccd1 vccd1 _0486_ sky130_fd_sc_hd__clkbuf_1
XFILLER_0_19_300 vssd1 vssd1 vccd1 vccd1 sky130_fd_sc_hd__decap_4
XFILLER_0_22_509 vssd1 vssd1 vccd1 vccd1 sky130_fd_sc_hd__fill_1
XFILLER_0_61_144 vccd1 vssd1 vccd1 vssd1 sky130_ef_sc_hd__decap_12
XFILLER_0_84_203 vssd1 vssd1 vccd1 vccd1 sky130_fd_sc_hd__fill_1
XFILLER_0_69_255 vssd1 vssd1 vccd1 vccd1 sky130_fd_sc_hd__decap_8
XFILLER_0_72_409 vssd1 vssd1 vccd1 vccd1 sky130_fd_sc_hd__decap_8
XFILLER_0_65_483 vccd1 vssd1 vccd1 vssd1 sky130_ef_sc_hd__decap_12
XFILLER_0_80_475 vssd1 vssd1 vccd1 vccd1 sky130_fd_sc_hd__fill_1
X_2300_ _0757_ vssd1 vssd1 vccd1 vccd1 _0758_ sky130_fd_sc_hd__buf_4
X_3280_ _1629_ _1630_ _1631_ net116 vssd1 vssd1 vccd1 vccd1 _0107_ sky130_fd_sc_hd__o31a_1
XTAP_704 vssd1 vccd1 sky130_fd_sc_hd__tapvpwrvgnd_1
XTAP_715 vssd1 vccd1 sky130_fd_sc_hd__tapvpwrvgnd_1
X_2231_ _0688_ u_imem.addr\[3\] vssd1 vssd1 vccd1 vccd1 _0689_ sky130_fd_sc_hd__and2b_1
XTAP_726 vssd1 vccd1 sky130_fd_sc_hd__tapvpwrvgnd_1
XTAP_737 vssd1 vccd1 sky130_fd_sc_hd__tapvpwrvgnd_1
XTAP_748 vssd1 vccd1 sky130_fd_sc_hd__tapvpwrvgnd_1
XTAP_759 vssd1 vccd1 sky130_fd_sc_hd__tapvpwrvgnd_1
X_2162_ net549 vssd1 vssd1 vccd1 vccd1 _0621_ sky130_fd_sc_hd__inv_2
XFILLER_0_75_225 vssd1 vssd1 vccd1 vccd1 sky130_fd_sc_hd__decap_8
XFILLER_0_48_439 vssd1 vssd1 vccd1 vccd1 sky130_fd_sc_hd__fill_1
XFILLER_0_28_141 vssd1 vssd1 vccd1 vccd1 sky130_fd_sc_hd__fill_2
X_4803_ clknet_leaf_10_clk _0571_ net21 vssd1 vssd1 vccd1 vccd1 u_audio.sample_reg\[4\]
+ sky130_fd_sc_hd__dfrtp_1
X_4734_ clknet_leaf_12_clk _0007_ net26 vssd1 vssd1 vccd1 vccd1 u_timer.count_reg\[0\]
+ sky130_fd_sc_hd__dfrtp_4
X_2995_ _1444_ _1448_ _1451_ _1452_ vssd1 vssd1 vccd1 vccd1 _1453_ sky130_fd_sc_hd__and4_1
XFILLER_0_83_291 vssd1 vssd1 vccd1 vccd1 sky130_fd_sc_hd__decap_6
XFILLER_0_16_347 vssd1 vssd1 vccd1 vccd1 sky130_fd_sc_hd__fill_1
X_4665_ clknet_leaf_38_clk _0466_ vssd1 vssd1 vccd1 vccd1 u_core.u_regfile.rf\[24\]\[3\]
+ sky130_fd_sc_hd__dfxtp_1
XFILLER_0_43_166 vssd1 vssd1 vccd1 vccd1 sky130_fd_sc_hd__fill_2
X_3616_ _1800_ vssd1 vssd1 vccd1 vccd1 _0274_ sky130_fd_sc_hd__clkbuf_1
X_4596_ clknet_leaf_22_clk _0397_ vssd1 vssd1 vccd1 vccd1 u_core.u_regfile.rf\[27\]\[30\]
+ sky130_fd_sc_hd__dfxtp_1
X_3547_ _1778_ vssd1 vssd1 vccd1 vccd1 _0227_ sky130_fd_sc_hd__clkbuf_1
X_3478_ _1158_ _1741_ _1742_ vssd1 vssd1 vccd1 vccd1 _0194_ sky130_fd_sc_hd__o21ai_1
X_2429_ _0757_ net20 u_core.u_regfile.rf\[6\]\[12\] vssd1 vssd1 vccd1 vccd1 _0887_
+ sky130_fd_sc_hd__o21ai_1
XFILLER_0_54_409 vssd1 vssd1 vccd1 vccd1 sky130_fd_sc_hd__decap_8
XFILLER_0_66_258 vssd1 vssd1 vccd1 vccd1 sky130_fd_sc_hd__fill_2
XFILLER_0_81_217 vssd1 vssd1 vccd1 vccd1 sky130_fd_sc_hd__decap_4
XFILLER_0_47_483 vccd1 vssd1 vccd1 vssd1 sky130_ef_sc_hd__decap_12
XFILLER_0_22_306 vssd1 vssd1 vccd1 vccd1 sky130_fd_sc_hd__fill_2
XFILLER_0_85_501 vssd1 vssd1 vccd1 vccd1 sky130_fd_sc_hd__decap_3
XFILLER_0_15_57 vssd1 vssd1 vccd1 vccd1 sky130_fd_sc_hd__decap_4
XFILLER_0_57_225 vssd1 vssd1 vccd1 vccd1 sky130_fd_sc_hd__decap_6
X_2780_ _1236_ _1237_ vssd1 vssd1 vccd1 vccd1 _1238_ sky130_fd_sc_hd__nand2_1
X_4450_ clknet_leaf_49_clk _0251_ vssd1 vssd1 vccd1 vccd1 u_core.u_regfile.rf\[7\]\[12\]
+ sky130_fd_sc_hd__dfxtp_1
XFILLER_0_53_486 vssd1 vssd1 vccd1 vccd1 sky130_fd_sc_hd__decap_8
Xhold207 u_core.u_regfile.rf\[26\]\[4\] vssd1 vssd1 vccd1 vccd1 net240 sky130_fd_sc_hd__dlygate4sd3_1
Xhold218 u_core.u_regfile.rf\[27\]\[29\] vssd1 vssd1 vccd1 vccd1 net251 sky130_fd_sc_hd__dlygate4sd3_1
Xhold229 u_core.u_regfile.rf\[3\]\[7\] vssd1 vssd1 vccd1 vccd1 net262 sky130_fd_sc_hd__dlygate4sd3_1
X_3401_ _1360_ _1411_ _1684_ vssd1 vssd1 vccd1 vccd1 _1685_ sky130_fd_sc_hd__nor3_1
X_4381_ clknet_leaf_19_clk _0192_ net27 vssd1 vssd1 vccd1 vccd1 u_timer.threshold_reg\[17\]
+ sky130_fd_sc_hd__dfrtp_1
X_3332_ net419 vssd1 vssd1 vccd1 vccd1 _1657_ sky130_fd_sc_hd__clkbuf_1
XFILLER_0_0_277 vssd1 vssd1 vccd1 vccd1 sky130_fd_sc_hd__decap_3
XTAP_501 vssd1 vccd1 sky130_fd_sc_hd__tapvpwrvgnd_1
XTAP_512 vssd1 vccd1 sky130_fd_sc_hd__tapvpwrvgnd_1
XTAP_523 vssd1 vccd1 sky130_fd_sc_hd__tapvpwrvgnd_1
XTAP_534 vssd1 vccd1 sky130_fd_sc_hd__tapvpwrvgnd_1
X_3263_ _1626_ _1627_ _1628_ net72 vssd1 vssd1 vccd1 vccd1 _0093_ sky130_fd_sc_hd__o31a_1
XTAP_545 vssd1 vccd1 sky130_fd_sc_hd__tapvpwrvgnd_1
XTAP_556 vssd1 vccd1 sky130_fd_sc_hd__tapvpwrvgnd_1
XTAP_567 vssd1 vccd1 sky130_fd_sc_hd__tapvpwrvgnd_1
X_2214_ u_timer.threshold_reg\[21\] vssd1 vssd1 vccd1 vccd1 _0673_ sky130_fd_sc_hd__inv_2
XTAP_578 vssd1 vccd1 sky130_fd_sc_hd__tapvpwrvgnd_1
XTAP_589 vssd1 vccd1 sky130_fd_sc_hd__tapvpwrvgnd_1
X_3194_ _1598_ vssd1 vssd1 vccd1 vccd1 _0054_ sky130_fd_sc_hd__clkbuf_1
XFILLER_0_56_53 vssd1 vssd1 vccd1 vccd1 sky130_fd_sc_hd__decap_3
X_2145_ u_timer.threshold_reg\[18\] vssd1 vssd1 vccd1 vccd1 _0604_ sky130_fd_sc_hd__inv_2
XFILLER_0_76_501 vssd1 vssd1 vccd1 vccd1 sky130_fd_sc_hd__decap_8
XFILLER_0_72_41 vccd1 vssd1 vccd1 vssd1 sky130_ef_sc_hd__decap_12
XFILLER_0_72_85 vssd1 vssd1 vccd1 vccd1 sky130_fd_sc_hd__decap_8
XFILLER_0_48_214 vssd1 vssd1 vccd1 vccd1 sky130_fd_sc_hd__fill_2
X_2978_ _1086_ _1087_ _1101_ _1435_ vssd1 vssd1 vccd1 vccd1 _1436_ sky130_fd_sc_hd__a22o_1
X_4717_ clknet_leaf_31_clk _0518_ vssd1 vssd1 vccd1 vccd1 u_core.u_regfile.rf\[25\]\[23\]
+ sky130_fd_sc_hd__dfxtp_1
X_4648_ clknet_leaf_26_clk _0449_ vssd1 vssd1 vccd1 vccd1 u_core.u_regfile.rf\[26\]\[18\]
+ sky130_fd_sc_hd__dfxtp_1
XFILLER_0_31_169 vssd1 vssd1 vccd1 vccd1 sky130_fd_sc_hd__decap_3
X_4579_ clknet_leaf_23_clk _0380_ vssd1 vssd1 vccd1 vccd1 u_core.u_regfile.rf\[27\]\[13\]
+ sky130_fd_sc_hd__dfxtp_1
XFILLER_0_79_372 vccd1 vssd1 vccd1 vssd1 sky130_ef_sc_hd__decap_12
XFILLER_0_39_269 vssd1 vssd1 vccd1 vccd1 sky130_fd_sc_hd__fill_1
XFILLER_0_54_228 vccd1 vssd1 vccd1 vssd1 sky130_ef_sc_hd__decap_12
XFILLER_0_2_509 vssd1 vssd1 vccd1 vccd1 sky130_fd_sc_hd__fill_1
XFILLER_0_22_125 vssd1 vssd1 vccd1 vccd1 sky130_fd_sc_hd__decap_3
XFILLER_0_10_309 vssd1 vssd1 vccd1 vccd1 sky130_fd_sc_hd__decap_8
Xhold90 u_core.u_regfile.rf\[6\]\[13\] vssd1 vssd1 vccd1 vccd1 net123 sky130_fd_sc_hd__dlygate4sd3_1
X_3950_ net218 vssd1 vssd1 vccd1 vccd1 _1971_ sky130_fd_sc_hd__clkbuf_1
X_2901_ _1191_ _1356_ _1358_ vssd1 vssd1 vccd1 vccd1 _1359_ sky130_fd_sc_hd__o21ai_2
X_3881_ _1936_ vssd1 vssd1 vccd1 vccd1 _0403_ sky130_fd_sc_hd__clkbuf_1
X_2832_ _0780_ _1158_ _1162_ vssd1 vssd1 vccd1 vccd1 _1290_ sky130_fd_sc_hd__nor3_1
X_2763_ _1210_ _1214_ _1220_ _0735_ vssd1 vssd1 vccd1 vccd1 _1221_ sky130_fd_sc_hd__and4b_1
X_4502_ clknet_leaf_35_clk _0303_ vssd1 vssd1 vccd1 vccd1 u_core.u_regfile.rf\[2\]\[0\]
+ sky130_fd_sc_hd__dfxtp_1
X_2694_ _1131_ _1142_ _1151_ vssd1 vssd1 vccd1 vccd1 _1152_ sky130_fd_sc_hd__a21oi_2
X_4433_ clknet_leaf_9_clk _0043_ net21 vssd1 vssd1 vccd1 vccd1 u_audio.counter\[4\]
+ sky130_fd_sc_hd__dfrtp_1
X_4364_ clknet_leaf_12_clk _0175_ net26 vssd1 vssd1 vccd1 vccd1 u_timer.threshold_reg\[0\]
+ sky130_fd_sc_hd__dfrtp_1
XTAP_342 vssd1 vccd1 sky130_fd_sc_hd__tapvpwrvgnd_1
XTAP_331 vssd1 vccd1 sky130_fd_sc_hd__tapvpwrvgnd_1
XTAP_320 vssd1 vccd1 sky130_fd_sc_hd__tapvpwrvgnd_1
X_3315_ _1648_ vssd1 vssd1 vccd1 vccd1 _0125_ sky130_fd_sc_hd__clkbuf_1
X_4295_ clknet_leaf_2_clk _0106_ vssd1 vssd1 vccd1 vccd1 u_core.u_regfile.rf\[6\]\[27\]
+ sky130_fd_sc_hd__dfxtp_1
X_3246_ _1623_ _1624_ _1625_ net119 vssd1 vssd1 vccd1 vccd1 _0079_ sky130_fd_sc_hd__o31a_1
XTAP_353 vssd1 vccd1 sky130_fd_sc_hd__tapvpwrvgnd_1
XTAP_364 vssd1 vccd1 sky130_fd_sc_hd__tapvpwrvgnd_1
XTAP_375 vssd1 vccd1 sky130_fd_sc_hd__tapvpwrvgnd_1
XTAP_386 vssd1 vccd1 sky130_fd_sc_hd__tapvpwrvgnd_1
XTAP_397 vssd1 vccd1 sky130_fd_sc_hd__tapvpwrvgnd_1
XFILLER_0_83_51 vssd1 vssd1 vccd1 vccd1 sky130_fd_sc_hd__decap_4
XFILLER_0_20_3 vccd1 vssd1 vccd1 vssd1 sky130_ef_sc_hd__decap_12
X_3177_ _1589_ _1590_ vssd1 vssd1 vccd1 vccd1 _0045_ sky130_fd_sc_hd__nor2_1
X_2128_ u_timer.count_reg\[25\] _0584_ vssd1 vssd1 vccd1 vccd1 _0587_ sky130_fd_sc_hd__nor2_1
XPHY_26 vssd1 vssd1 vccd1 vccd1 sky130_fd_sc_hd__decap_3
XPHY_15 vssd1 vssd1 vccd1 vccd1 sky130_fd_sc_hd__decap_3
XPHY_37 vssd1 vssd1 vccd1 vccd1 sky130_fd_sc_hd__decap_3
XPHY_48 vssd1 vssd1 vccd1 vccd1 sky130_fd_sc_hd__decap_3
XPHY_59 vssd1 vssd1 vccd1 vccd1 sky130_fd_sc_hd__decap_3
XFILLER_0_76_386 vssd1 vssd1 vccd1 vccd1 sky130_fd_sc_hd__decap_8
XFILLER_0_17_464 vccd1 vssd1 vccd1 vssd1 sky130_ef_sc_hd__decap_12
XFILLER_0_32_467 vssd1 vssd1 vccd1 vccd1 sky130_fd_sc_hd__decap_8
XFILLER_0_44_294 vssd1 vssd1 vccd1 vccd1 sky130_fd_sc_hd__decap_4
XFILLER_0_42_209 vssd1 vssd1 vccd1 vccd1 sky130_fd_sc_hd__fill_1
XFILLER_0_82_389 vccd1 vssd1 vccd1 vssd1 sky130_ef_sc_hd__decap_12
X_3100_ u_timer.count_reg\[18\] _1532_ _1534_ _1490_ vssd1 vssd1 vccd1 vccd1 _0016_
+ sky130_fd_sc_hd__o211a_1
XFILLER_0_37_11 vssd1 vssd1 vccd1 vccd1 sky130_fd_sc_hd__decap_3
XFILLER_0_37_44 vssd1 vssd1 vccd1 vccd1 sky130_fd_sc_hd__fill_1
X_4080_ net355 vssd1 vssd1 vccd1 vccd1 _2036_ sky130_fd_sc_hd__clkbuf_1
X_3031_ _0752_ _0698_ _1485_ vssd1 vssd1 vccd1 vccd1 _0005_ sky130_fd_sc_hd__a21oi_1
XFILLER_0_58_320 vssd1 vssd1 vccd1 vccd1 sky130_fd_sc_hd__fill_1
XFILLER_0_58_342 vssd1 vssd1 vccd1 vccd1 sky130_fd_sc_hd__fill_2
X_3933_ _1962_ vssd1 vssd1 vccd1 vccd1 _0429_ sky130_fd_sc_hd__clkbuf_1
X_3864_ net332 vssd1 vssd1 vccd1 vccd1 _1928_ sky130_fd_sc_hd__clkbuf_1
X_2815_ _1209_ _1272_ vssd1 vssd1 vccd1 vccd1 _1273_ sky130_fd_sc_hd__or2_1
X_3795_ _1377_ _1378_ _0783_ _1893_ vssd1 vssd1 vccd1 vccd1 _0360_ sky130_fd_sc_hd__a31o_1
X_2746_ u_core.u_regfile.rf\[31\]\[17\] _0726_ _0745_ _0803_ vssd1 vssd1 vccd1 vccd1
+ _1204_ sky130_fd_sc_hd__o22a_2
X_2677_ _0813_ _1122_ _1123_ _1124_ vssd1 vssd1 vccd1 vccd1 _1135_ sky130_fd_sc_hd__a31oi_4
XFILLER_0_1_361 vccd1 vssd1 vccd1 vssd1 sky130_ef_sc_hd__decap_12
X_4416_ clknet_leaf_26_clk _0227_ vssd1 vssd1 vccd1 vccd1 u_core.u_regfile.rf\[29\]\[20\]
+ sky130_fd_sc_hd__dfxtp_1
XFILLER_0_68_3 vccd1 vssd1 vccd1 vssd1 sky130_ef_sc_hd__decap_12
X_4347_ clknet_leaf_30_clk _0158_ vssd1 vssd1 vccd1 vccd1 u_core.u_regfile.rf\[5\]\[15\]
+ sky130_fd_sc_hd__dfxtp_1
X_4278_ clknet_leaf_47_clk _0089_ vssd1 vssd1 vccd1 vccd1 u_core.u_regfile.rf\[6\]\[10\]
+ sky130_fd_sc_hd__dfxtp_1
XTAP_172 vssd1 vccd1 sky130_fd_sc_hd__tapvpwrvgnd_1
XTAP_183 vssd1 vccd1 sky130_fd_sc_hd__tapvpwrvgnd_1
XTAP_194 vssd1 vccd1 sky130_fd_sc_hd__tapvpwrvgnd_1
X_3229_ u_core.u_regfile.rf\[31\]\[25\] vssd1 vssd1 vccd1 vccd1 _1616_ sky130_fd_sc_hd__clkbuf_1
XFILLER_0_64_301 vssd1 vssd1 vccd1 vccd1 sky130_fd_sc_hd__fill_2
XFILLER_0_24_209 vssd1 vssd1 vccd1 vccd1 sky130_fd_sc_hd__fill_2
Xhold390 u_core.u_regfile.rf\[29\]\[2\] vssd1 vssd1 vccd1 vccd1 net423 sky130_fd_sc_hd__dlygate4sd3_1
XFILLER_0_82_186 vssd1 vssd1 vccd1 vccd1 sky130_fd_sc_hd__fill_1
X_3580_ _1486_ vssd1 vssd1 vccd1 vccd1 _1792_ sky130_fd_sc_hd__clkbuf_4
X_2600_ _0721_ u_core.u_regfile.rf\[31\]\[2\] vssd1 vssd1 vccd1 vccd1 _1058_ sky130_fd_sc_hd__and2_1
XFILLER_0_70_359 vssd1 vssd1 vccd1 vccd1 sky130_fd_sc_hd__decap_4
X_2531_ u_core.u_regfile.rf\[7\]\[11\] vssd1 vssd1 vccd1 vccd1 _0989_ sky130_fd_sc_hd__inv_2
XFILLER_0_2_125 vssd1 vssd1 vccd1 vccd1 sky130_fd_sc_hd__decap_8
X_4201_ _2100_ vssd1 vssd1 vccd1 vccd1 _0559_ sky130_fd_sc_hd__clkbuf_1
X_2462_ u_core.u_regfile.rf\[31\]\[15\] _0726_ _0858_ _0808_ vssd1 vssd1 vccd1 vccd1
+ _0920_ sky130_fd_sc_hd__a2bb2o_1
X_2393_ _0821_ _0847_ _0848_ _0850_ vssd1 vssd1 vccd1 vccd1 _0851_ sky130_fd_sc_hd__o211ai_1
X_4132_ _2063_ _1686_ _1737_ vssd1 vssd1 vccd1 vccd1 _2064_ sky130_fd_sc_hd__nand3b_1
X_4063_ _2027_ vssd1 vssd1 vccd1 vccd1 _0494_ sky130_fd_sc_hd__clkbuf_1
X_3014_ _1470_ _1471_ vssd1 vssd1 vccd1 vccd1 _1472_ sky130_fd_sc_hd__nor2_1
XFILLER_0_78_404 vccd1 vssd1 vccd1 vssd1 sky130_ef_sc_hd__decap_12
XFILLER_0_3_89 vssd1 vssd1 vccd1 vccd1 sky130_fd_sc_hd__decap_3
Xwire13 net564 vssd1 vssd1 vccd1 vccd1 net13 sky130_fd_sc_hd__clkbuf_2
XFILLER_0_80_41 vccd1 vssd1 vccd1 vssd1 sky130_ef_sc_hd__decap_12
X_3916_ net396 vssd1 vssd1 vccd1 vccd1 _1954_ sky130_fd_sc_hd__clkbuf_1
XFILLER_0_80_85 vccd1 vssd1 vccd1 vssd1 sky130_ef_sc_hd__decap_12
XFILLER_0_46_356 vssd1 vssd1 vccd1 vccd1 sky130_fd_sc_hd__decap_8
XFILLER_0_73_164 vssd1 vssd1 vccd1 vccd1 sky130_fd_sc_hd__fill_1
X_3847_ _1919_ vssd1 vssd1 vccd1 vccd1 _0386_ sky130_fd_sc_hd__clkbuf_1
XFILLER_0_6_464 vssd1 vssd1 vccd1 vccd1 sky130_fd_sc_hd__fill_2
X_3778_ _1876_ _1877_ net518 vssd1 vssd1 vccd1 vccd1 _1885_ sky130_fd_sc_hd__o21a_1
XFILLER_0_14_253 vssd1 vssd1 vccd1 vccd1 sky130_fd_sc_hd__decap_4
X_2729_ _0922_ _0954_ u_core.u_regfile.rf\[28\]\[18\] vssd1 vssd1 vccd1 vccd1 _1187_
+ sky130_fd_sc_hd__o21a_1
XFILLER_0_77_492 vccd1 vssd1 vccd1 vssd1 sky130_ef_sc_hd__decap_12
XFILLER_0_52_359 vssd1 vssd1 vccd1 vccd1 sky130_fd_sc_hd__decap_4
XFILLER_0_64_197 vssd1 vssd1 vccd1 vccd1 sky130_fd_sc_hd__decap_3
XTAP_908 vssd1 vccd1 sky130_fd_sc_hd__tapvpwrvgnd_1
XTAP_919 vssd1 vccd1 sky130_fd_sc_hd__tapvpwrvgnd_1
XFILLER_0_18_79 vssd1 vssd1 vccd1 vccd1 sky130_fd_sc_hd__fill_1
XFILLER_0_75_407 vccd1 vssd1 vccd1 vssd1 sky130_ef_sc_hd__decap_12
XFILLER_0_28_312 vssd1 vssd1 vccd1 vccd1 sky130_fd_sc_hd__fill_1
XFILLER_0_68_470 vssd1 vssd1 vccd1 vccd1 sky130_fd_sc_hd__fill_2
X_4750_ clknet_leaf_21_clk _0014_ net31 vssd1 vssd1 vccd1 vccd1 u_timer.count_reg\[16\]
+ sky130_fd_sc_hd__dfrtp_2
XFILLER_0_83_473 vccd1 vssd1 vccd1 vssd1 sky130_ef_sc_hd__decap_12
X_3701_ net227 vssd1 vssd1 vccd1 vccd1 _1843_ sky130_fd_sc_hd__clkbuf_1
X_4681_ clknet_leaf_34_clk _0482_ vssd1 vssd1 vccd1 vccd1 u_core.u_regfile.rf\[24\]\[19\]
+ sky130_fd_sc_hd__dfxtp_1
X_3632_ _1808_ vssd1 vssd1 vccd1 vccd1 _0282_ sky130_fd_sc_hd__clkbuf_1
XFILLER_0_50_88 vssd1 vssd1 vccd1 vccd1 sky130_fd_sc_hd__fill_2
XFILLER_0_70_123 vccd1 vssd1 vccd1 vssd1 sky130_ef_sc_hd__decap_12
X_3563_ _1786_ vssd1 vssd1 vccd1 vccd1 _0235_ sky130_fd_sc_hd__clkbuf_1
X_3494_ _0816_ _1741_ _1751_ vssd1 vssd1 vccd1 vccd1 _0201_ sky130_fd_sc_hd__o21ai_1
X_2514_ _0866_ u_core.u_regfile.rf\[1\]\[10\] _0857_ _0867_ vssd1 vssd1 vccd1 vccd1
+ _0972_ sky130_fd_sc_hd__a31o_1
X_2445_ _0687_ _0720_ _0778_ _0725_ vssd1 vssd1 vccd1 vccd1 _0903_ sky130_fd_sc_hd__a2bb2oi_4
X_2376_ _0738_ _0762_ u_core.u_regfile.rf\[6\]\[24\] vssd1 vssd1 vccd1 vccd1 _0834_
+ sky130_fd_sc_hd__o21a_1
X_4115_ _2053_ vssd1 vssd1 vccd1 vccd1 _0520_ sky130_fd_sc_hd__clkbuf_1
X_4046_ net358 vssd1 vssd1 vccd1 vccd1 _2019_ sky130_fd_sc_hd__clkbuf_1
XFILLER_0_66_418 vssd1 vssd1 vccd1 vccd1 sky130_fd_sc_hd__fill_2
XFILLER_0_66_429 vssd1 vssd1 vccd1 vccd1 sky130_fd_sc_hd__fill_1
XFILLER_0_19_389 vssd1 vssd1 vccd1 vccd1 sky130_fd_sc_hd__decap_3
XFILLER_0_34_337 vssd1 vssd1 vccd1 vccd1 sky130_fd_sc_hd__decap_3
XFILLER_0_34_348 vssd1 vssd1 vccd1 vccd1 sky130_fd_sc_hd__decap_4
XFILLER_0_46_197 vssd1 vssd1 vccd1 vccd1 sky130_fd_sc_hd__decap_8
XFILLER_0_61_156 vssd1 vssd1 vccd1 vccd1 sky130_fd_sc_hd__fill_1
XFILLER_0_61_178 vssd1 vssd1 vccd1 vccd1 sky130_fd_sc_hd__decap_6
XFILLER_0_69_223 vssd1 vssd1 vccd1 vccd1 sky130_fd_sc_hd__fill_1
XFILLER_0_84_248 vssd1 vssd1 vccd1 vccd1 sky130_fd_sc_hd__decap_4
XFILLER_0_80_421 vccd1 vssd1 vccd1 vssd1 sky130_ef_sc_hd__decap_12
XFILLER_0_25_337 vssd1 vssd1 vccd1 vccd1 sky130_fd_sc_hd__decap_6
XFILLER_0_25_359 vssd1 vssd1 vccd1 vccd1 sky130_fd_sc_hd__fill_2
XFILLER_0_52_112 vssd1 vssd1 vccd1 vccd1 sky130_fd_sc_hd__fill_1
XFILLER_0_65_495 vssd1 vssd1 vccd1 vccd1 sky130_fd_sc_hd__decap_8
XFILLER_0_40_307 vssd1 vssd1 vccd1 vccd1 sky130_fd_sc_hd__fill_1
XFILLER_0_52_178 vssd1 vssd1 vccd1 vccd1 sky130_fd_sc_hd__fill_1
XTAP_705 vssd1 vccd1 sky130_fd_sc_hd__tapvpwrvgnd_1
XTAP_716 vssd1 vccd1 sky130_fd_sc_hd__tapvpwrvgnd_1
X_2230_ u_imem.addr\[2\] vssd1 vssd1 vccd1 vccd1 _0688_ sky130_fd_sc_hd__buf_4
XTAP_727 vssd1 vccd1 sky130_fd_sc_hd__tapvpwrvgnd_1
XTAP_738 vssd1 vccd1 sky130_fd_sc_hd__tapvpwrvgnd_1
XTAP_749 vssd1 vccd1 sky130_fd_sc_hd__tapvpwrvgnd_1
X_2161_ net546 vssd1 vssd1 vccd1 vccd1 _0620_ sky130_fd_sc_hd__inv_2
XFILLER_0_48_418 vssd1 vssd1 vccd1 vccd1 sky130_fd_sc_hd__fill_2
XFILLER_0_0_57 vccd1 vssd1 vccd1 vssd1 sky130_ef_sc_hd__decap_12
X_2994_ _0967_ _1450_ _1449_ vssd1 vssd1 vccd1 vccd1 _1452_ sky130_fd_sc_hd__a21o_2
X_4802_ clknet_leaf_10_clk _0570_ net21 vssd1 vssd1 vccd1 vccd1 u_audio.sample_reg\[3\]
+ sky130_fd_sc_hd__dfrtp_1
X_4733_ clknet_leaf_16_clk _0534_ net23 vssd1 vssd1 vccd1 vccd1 net10 sky130_fd_sc_hd__dfrtp_1
XFILLER_0_28_186 vssd1 vssd1 vccd1 vccd1 sky130_fd_sc_hd__fill_1
XFILLER_0_9_55 vssd1 vssd1 vccd1 vccd1 sky130_fd_sc_hd__fill_1
X_4664_ clknet_leaf_25_clk _0465_ vssd1 vssd1 vccd1 vccd1 u_core.u_regfile.rf\[24\]\[2\]
+ sky130_fd_sc_hd__dfxtp_1
X_4595_ clknet_leaf_23_clk _0396_ vssd1 vssd1 vccd1 vccd1 u_core.u_regfile.rf\[27\]\[29\]
+ sky130_fd_sc_hd__dfxtp_1
XFILLER_0_3_231 vssd1 vssd1 vccd1 vccd1 sky130_fd_sc_hd__fill_1
X_3615_ net193 vssd1 vssd1 vccd1 vccd1 _1800_ sky130_fd_sc_hd__clkbuf_1
X_3546_ net428 vssd1 vssd1 vccd1 vccd1 _1778_ sky130_fd_sc_hd__clkbuf_1
XFILLER_0_50_3 vccd1 vssd1 vccd1 vssd1 sky130_ef_sc_hd__decap_12
X_3477_ _1731_ _1725_ _1739_ _1726_ _0603_ vssd1 vssd1 vccd1 vccd1 _1742_ sky130_fd_sc_hd__a41o_1
X_2428_ _0860_ u_core.u_regfile.rf\[7\]\[12\] _0713_ vssd1 vssd1 vccd1 vccd1 _0886_
+ sky130_fd_sc_hd__nand3_1
X_2359_ u_core.u_regfile.rf\[29\]\[26\] u_core.u_regfile.rf\[31\]\[26\] _0705_ vssd1
+ vssd1 vccd1 vccd1 _0817_ sky130_fd_sc_hd__mux2_1
X_4029_ _2010_ vssd1 vssd1 vccd1 vccd1 _0477_ sky130_fd_sc_hd__clkbuf_1
XFILLER_0_47_495 vssd1 vssd1 vccd1 vccd1 sky130_fd_sc_hd__decap_8
XFILLER_0_34_167 vssd1 vssd1 vccd1 vccd1 sky130_fd_sc_hd__decap_3
XFILLER_0_34_178 vssd1 vssd1 vccd1 vccd1 sky130_fd_sc_hd__fill_2
XFILLER_0_30_362 vssd1 vssd1 vccd1 vccd1 sky130_fd_sc_hd__fill_2
XFILLER_0_30_373 vssd1 vssd1 vccd1 vccd1 sky130_fd_sc_hd__fill_1
XFILLER_0_31_13 vssd1 vssd1 vccd1 vccd1 sky130_fd_sc_hd__decap_8
XFILLER_0_25_134 vssd1 vssd1 vccd1 vccd1 sky130_fd_sc_hd__decap_4
XFILLER_0_31_57 vssd1 vssd1 vccd1 vccd1 sky130_fd_sc_hd__decap_4
XFILLER_0_65_270 vssd1 vssd1 vccd1 vccd1 sky130_fd_sc_hd__decap_8
XFILLER_0_65_281 vssd1 vssd1 vccd1 vccd1 sky130_fd_sc_hd__decap_4
XFILLER_0_80_240 vssd1 vssd1 vccd1 vccd1 sky130_fd_sc_hd__decap_6
Xhold208 u_core.u_regfile.rf\[24\]\[29\] vssd1 vssd1 vccd1 vccd1 net241 sky130_fd_sc_hd__dlygate4sd3_1
XFILLER_0_21_340 vssd1 vssd1 vccd1 vccd1 sky130_fd_sc_hd__fill_1
XFILLER_0_40_148 vssd1 vssd1 vccd1 vccd1 sky130_fd_sc_hd__decap_3
X_3400_ _0768_ _1477_ _1478_ vssd1 vssd1 vccd1 vccd1 _1684_ sky130_fd_sc_hd__o21a_1
Xhold219 u_core.u_regfile.rf\[25\]\[18\] vssd1 vssd1 vccd1 vccd1 net252 sky130_fd_sc_hd__dlygate4sd3_1
X_4380_ clknet_leaf_20_clk _0191_ net30 vssd1 vssd1 vccd1 vccd1 u_timer.threshold_reg\[16\]
+ sky130_fd_sc_hd__dfrtp_1
X_3331_ _1656_ vssd1 vssd1 vccd1 vccd1 _0133_ sky130_fd_sc_hd__clkbuf_1
XFILLER_0_21_373 vssd1 vssd1 vccd1 vccd1 sky130_fd_sc_hd__decap_8
XTAP_502 vssd1 vccd1 sky130_fd_sc_hd__tapvpwrvgnd_1
XTAP_513 vssd1 vccd1 sky130_fd_sc_hd__tapvpwrvgnd_1
XTAP_524 vssd1 vccd1 sky130_fd_sc_hd__tapvpwrvgnd_1
X_3262_ _1626_ _1627_ _1628_ net123 vssd1 vssd1 vccd1 vccd1 _0092_ sky130_fd_sc_hd__o31a_1
XTAP_535 vssd1 vccd1 sky130_fd_sc_hd__tapvpwrvgnd_1
XTAP_546 vssd1 vccd1 sky130_fd_sc_hd__tapvpwrvgnd_1
XTAP_557 vssd1 vccd1 sky130_fd_sc_hd__tapvpwrvgnd_1
X_2213_ u_timer.count_reg\[22\] _0600_ _0602_ _0671_ vssd1 vssd1 vccd1 vccd1 _0672_
+ sky130_fd_sc_hd__a31o_1
XTAP_568 vssd1 vccd1 sky130_fd_sc_hd__tapvpwrvgnd_1
XTAP_579 vssd1 vccd1 sky130_fd_sc_hd__tapvpwrvgnd_1
X_3193_ net528 vssd1 vssd1 vccd1 vccd1 _1598_ sky130_fd_sc_hd__clkbuf_1
X_2144_ u_timer.threshold_reg\[19\] vssd1 vssd1 vccd1 vccd1 _0603_ sky130_fd_sc_hd__inv_2
XFILLER_0_72_53 vccd1 vssd1 vccd1 vssd1 sky130_ef_sc_hd__decap_12
XFILLER_0_48_226 vccd1 vssd1 vccd1 vssd1 sky130_ef_sc_hd__decap_12
XFILLER_0_29_495 vssd1 vssd1 vccd1 vccd1 sky130_fd_sc_hd__fill_1
X_2977_ _1100_ _1101_ _1073_ vssd1 vssd1 vccd1 vccd1 _1435_ sky130_fd_sc_hd__nand3_1
XFILLER_0_56_281 vssd1 vssd1 vccd1 vccd1 sky130_fd_sc_hd__decap_4
X_4716_ clknet_leaf_39_clk _0517_ vssd1 vssd1 vccd1 vccd1 u_core.u_regfile.rf\[25\]\[22\]
+ sky130_fd_sc_hd__dfxtp_1
XFILLER_0_71_273 vssd1 vssd1 vccd1 vccd1 sky130_fd_sc_hd__decap_6
X_4647_ clknet_leaf_35_clk _0448_ vssd1 vssd1 vccd1 vccd1 u_core.u_regfile.rf\[26\]\[17\]
+ sky130_fd_sc_hd__dfxtp_1
XFILLER_0_44_498 vccd1 vssd1 vccd1 vssd1 sky130_ef_sc_hd__decap_12
X_4578_ clknet_leaf_39_clk _0379_ vssd1 vssd1 vccd1 vccd1 u_core.u_regfile.rf\[27\]\[12\]
+ sky130_fd_sc_hd__dfxtp_1
X_3529_ _1769_ vssd1 vssd1 vccd1 vccd1 _0218_ sky130_fd_sc_hd__clkbuf_1
XFILLER_0_79_384 vssd1 vssd1 vccd1 vccd1 sky130_fd_sc_hd__decap_8
XFILLER_0_62_251 vssd1 vssd1 vccd1 vccd1 sky130_fd_sc_hd__fill_1
XFILLER_0_62_273 vssd1 vssd1 vccd1 vccd1 sky130_fd_sc_hd__decap_3
XFILLER_0_50_468 vssd1 vssd1 vccd1 vccd1 sky130_fd_sc_hd__fill_1
Xhold80 u_core.u_regfile.rf\[7\]\[1\] vssd1 vssd1 vccd1 vccd1 net113 sky130_fd_sc_hd__dlygate4sd3_1
Xhold91 u_core.u_regfile.rf\[6\]\[6\] vssd1 vssd1 vccd1 vccd1 net124 sky130_fd_sc_hd__dlygate4sd3_1
XFILLER_0_85_321 vccd1 vssd1 vccd1 vssd1 sky130_ef_sc_hd__decap_12
X_2900_ _1163_ _1165_ _1191_ _1357_ vssd1 vssd1 vccd1 vccd1 _1358_ sky130_fd_sc_hd__o2bb2ai_1
XFILLER_0_85_365 vccd1 vssd1 vccd1 vssd1 sky130_ef_sc_hd__decap_12
XFILLER_0_73_505 vssd1 vssd1 vccd1 vccd1 sky130_fd_sc_hd__decap_4
X_3880_ net393 vssd1 vssd1 vccd1 vccd1 _1936_ sky130_fd_sc_hd__clkbuf_1
XFILLER_0_42_56 vssd1 vssd1 vccd1 vccd1 sky130_fd_sc_hd__fill_1
X_2831_ _1163_ _1165_ _1190_ vssd1 vssd1 vccd1 vccd1 _1289_ sky130_fd_sc_hd__a21oi_1
XFILLER_0_5_337 vssd1 vssd1 vccd1 vccd1 sky130_fd_sc_hd__decap_3
X_2762_ _0813_ _1217_ _1218_ _1219_ vssd1 vssd1 vccd1 vccd1 _1220_ sky130_fd_sc_hd__a31o_2
XFILLER_0_26_465 vssd1 vssd1 vccd1 vccd1 sky130_fd_sc_hd__fill_1
XFILLER_0_13_104 vssd1 vssd1 vccd1 vccd1 sky130_fd_sc_hd__decap_8
X_4501_ clknet_leaf_35_clk _0302_ vssd1 vssd1 vccd1 vccd1 u_core.u_regfile.rf\[30\]\[31\]
+ sky130_fd_sc_hd__dfxtp_1
XFILLER_0_41_413 vccd1 vssd1 vccd1 vssd1 sky130_ef_sc_hd__decap_12
X_2693_ _1150_ _0936_ vssd1 vssd1 vccd1 vccd1 _1151_ sky130_fd_sc_hd__or2_2
XFILLER_0_41_446 vssd1 vssd1 vccd1 vccd1 sky130_fd_sc_hd__fill_2
X_4432_ clknet_leaf_10_clk _0042_ net21 vssd1 vssd1 vccd1 vccd1 u_audio.counter\[3\]
+ sky130_fd_sc_hd__dfrtp_1
XFILLER_0_6_45 vssd1 vssd1 vccd1 vccd1 sky130_fd_sc_hd__fill_1
X_4363_ clknet_leaf_6_clk _0174_ vssd1 vssd1 vccd1 vccd1 u_core.u_regfile.rf\[5\]\[31\]
+ sky130_fd_sc_hd__dfxtp_1
XTAP_332 vssd1 vccd1 sky130_fd_sc_hd__tapvpwrvgnd_1
XTAP_321 vssd1 vccd1 sky130_fd_sc_hd__tapvpwrvgnd_1
XTAP_310 vssd1 vccd1 sky130_fd_sc_hd__tapvpwrvgnd_1
X_3314_ net490 vssd1 vssd1 vccd1 vccd1 _1648_ sky130_fd_sc_hd__clkbuf_1
X_4294_ clknet_leaf_2_clk _0105_ vssd1 vssd1 vccd1 vccd1 u_core.u_regfile.rf\[6\]\[26\]
+ sky130_fd_sc_hd__dfxtp_1
XTAP_343 vssd1 vccd1 sky130_fd_sc_hd__tapvpwrvgnd_1
X_3245_ _1483_ vssd1 vssd1 vccd1 vccd1 _1625_ sky130_fd_sc_hd__buf_2
XTAP_354 vssd1 vccd1 sky130_fd_sc_hd__tapvpwrvgnd_1
XTAP_365 vssd1 vccd1 sky130_fd_sc_hd__tapvpwrvgnd_1
XTAP_376 vssd1 vccd1 sky130_fd_sc_hd__tapvpwrvgnd_1
XTAP_387 vssd1 vccd1 sky130_fd_sc_hd__tapvpwrvgnd_1
XTAP_398 vssd1 vccd1 sky130_fd_sc_hd__tapvpwrvgnd_1
X_3176_ net515 _1587_ vssd1 vssd1 vccd1 vccd1 _1590_ sky130_fd_sc_hd__nor2_1
X_2127_ u_timer.count_reg\[25\] _0584_ _0585_ u_timer.threshold_reg\[24\] vssd1 vssd1
+ vccd1 vccd1 _0586_ sky130_fd_sc_hd__o2bb2a_1
XFILLER_0_13_3 vccd1 vssd1 vccd1 vssd1 sky130_ef_sc_hd__decap_12
XPHY_27 vssd1 vssd1 vccd1 vccd1 sky130_fd_sc_hd__decap_3
XPHY_16 vssd1 vssd1 vccd1 vccd1 sky130_fd_sc_hd__decap_3
XPHY_38 vssd1 vssd1 vccd1 vccd1 sky130_fd_sc_hd__decap_3
XFILLER_0_76_321 vssd1 vssd1 vccd1 vccd1 sky130_fd_sc_hd__decap_8
XPHY_49 vssd1 vssd1 vccd1 vccd1 sky130_fd_sc_hd__decap_3
XFILLER_0_29_281 vssd1 vssd1 vccd1 vccd1 sky130_fd_sc_hd__fill_2
XFILLER_0_8_197 vssd1 vssd1 vccd1 vccd1 sky130_fd_sc_hd__decap_4
XFILLER_0_17_476 vccd1 vssd1 vccd1 vssd1 sky130_ef_sc_hd__decap_12
XFILLER_0_4_392 vssd1 vssd1 vccd1 vccd1 sky130_fd_sc_hd__fill_1
XFILLER_0_12_181 vssd1 vssd1 vccd1 vccd1 sky130_fd_sc_hd__fill_2
XFILLER_0_55_505 vssd1 vssd1 vccd1 vccd1 sky130_fd_sc_hd__decap_4
XFILLER_0_12_15 vccd1 vssd1 vccd1 vssd1 sky130_ef_sc_hd__decap_12
XFILLER_0_12_59 vssd1 vssd1 vccd1 vccd1 sky130_fd_sc_hd__decap_4
XFILLER_0_12_37 vssd1 vssd1 vccd1 vccd1 sky130_fd_sc_hd__fill_2
XFILLER_0_2_307 vssd1 vssd1 vccd1 vccd1 sky130_fd_sc_hd__fill_1
XFILLER_0_50_298 vssd1 vssd1 vccd1 vccd1 sky130_fd_sc_hd__decap_8
Xoutput2 net2 vssd1 vssd1 vccd1 vccd1 audio_out sky130_fd_sc_hd__clkbuf_4
X_3030_ _1405_ _1484_ _0720_ net91 vssd1 vssd1 vccd1 vccd1 _1485_ sky130_fd_sc_hd__a31o_1
XFILLER_0_73_302 vssd1 vssd1 vccd1 vccd1 sky130_fd_sc_hd__fill_1
Xclkbuf_leaf_43_clk clknet_2_0__leaf_clk vssd1 vssd1 vccd1 vccd1 clknet_leaf_43_clk
+ sky130_fd_sc_hd__clkbuf_16
X_3932_ net474 vssd1 vssd1 vccd1 vccd1 _1962_ sky130_fd_sc_hd__clkbuf_1
X_3863_ _1927_ vssd1 vssd1 vccd1 vccd1 _0394_ sky130_fd_sc_hd__clkbuf_1
XFILLER_0_5_101 vssd1 vssd1 vccd1 vccd1 sky130_fd_sc_hd__fill_1
X_2814_ _1224_ _1238_ _1256_ _1271_ vssd1 vssd1 vccd1 vccd1 _1272_ sky130_fd_sc_hd__nand4_1
X_3794_ _1484_ _0737_ net483 vssd1 vssd1 vccd1 vccd1 _1893_ sky130_fd_sc_hd__o21a_1
X_2745_ _0770_ _0722_ _0693_ u_core.u_regfile.rf\[5\]\[17\] _1202_ vssd1 vssd1 vccd1
+ vccd1 _1203_ sky130_fd_sc_hd__o221a_2
XFILLER_0_78_41 vccd1 vssd1 vccd1 vssd1 sky130_ef_sc_hd__decap_12
X_2676_ u_core.u_regfile.rf\[31\]\[7\] _0727_ _1133_ _0759_ vssd1 vssd1 vccd1 vccd1
+ _1134_ sky130_fd_sc_hd__a2bb2o_1
XFILLER_0_78_85 vccd1 vssd1 vccd1 vssd1 sky130_ef_sc_hd__decap_12
X_4415_ clknet_leaf_28_clk _0226_ vssd1 vssd1 vccd1 vccd1 u_core.u_regfile.rf\[29\]\[19\]
+ sky130_fd_sc_hd__dfxtp_1
XFILLER_0_1_373 vccd1 vssd1 vccd1 vssd1 sky130_ef_sc_hd__decap_12
X_4346_ clknet_leaf_31_clk _0157_ vssd1 vssd1 vccd1 vccd1 u_core.u_regfile.rf\[5\]\[14\]
+ sky130_fd_sc_hd__dfxtp_1
X_4277_ clknet_leaf_49_clk _0088_ vssd1 vssd1 vccd1 vccd1 u_core.u_regfile.rf\[6\]\[9\]
+ sky130_fd_sc_hd__dfxtp_1
XTAP_173 vssd1 vccd1 sky130_fd_sc_hd__tapvpwrvgnd_1
XTAP_184 vssd1 vccd1 sky130_fd_sc_hd__tapvpwrvgnd_1
XTAP_195 vssd1 vccd1 sky130_fd_sc_hd__tapvpwrvgnd_1
X_3228_ _1615_ vssd1 vssd1 vccd1 vccd1 _0071_ sky130_fd_sc_hd__clkbuf_1
X_3159_ _1562_ u_audio.counter\[7\] _1563_ u_audio.counter\[5\] vssd1 vssd1 vccd1
+ vccd1 _1580_ sky130_fd_sc_hd__o2bb2a_1
Xclkbuf_leaf_34_clk clknet_2_1__leaf_clk vssd1 vssd1 vccd1 vccd1 clknet_leaf_34_clk
+ sky130_fd_sc_hd__clkbuf_16
XFILLER_0_2_3 vccd1 vssd1 vccd1 vssd1 sky130_ef_sc_hd__decap_12
Xhold380 u_core.u_regfile.rf\[4\]\[19\] vssd1 vssd1 vccd1 vccd1 net413 sky130_fd_sc_hd__dlygate4sd3_1
Xhold391 u_core.u_regfile.rf\[29\]\[24\] vssd1 vssd1 vccd1 vccd1 net424 sky130_fd_sc_hd__dlygate4sd3_1
XFILLER_0_23_36 vssd1 vssd1 vccd1 vccd1 sky130_fd_sc_hd__fill_1
XFILLER_0_28_505 vssd1 vssd1 vccd1 vccd1 sky130_fd_sc_hd__decap_4
Xclkbuf_leaf_25_clk clknet_2_3__leaf_clk vssd1 vssd1 vccd1 vccd1 clknet_leaf_25_clk
+ sky130_fd_sc_hd__clkbuf_16
XFILLER_0_55_335 vssd1 vssd1 vccd1 vccd1 sky130_fd_sc_hd__fill_1
XFILLER_0_43_508 vssd1 vssd1 vccd1 vccd1 sky130_fd_sc_hd__fill_2
XFILLER_0_23_221 vssd1 vssd1 vccd1 vccd1 sky130_fd_sc_hd__decap_3
X_2530_ u_core.u_regfile.rf\[5\]\[11\] _0876_ _0904_ _0952_ _0773_ vssd1 vssd1 vccd1
+ vccd1 _0988_ sky130_fd_sc_hd__o32a_2
X_2461_ _0780_ _0896_ _0906_ _0916_ _0918_ vssd1 vssd1 vccd1 vccd1 _0919_ sky130_fd_sc_hd__o41a_1
X_4200_ net247 vssd1 vssd1 vccd1 vccd1 _2100_ sky130_fd_sc_hd__clkbuf_1
X_2392_ _0807_ _0849_ vssd1 vssd1 vccd1 vccd1 _0850_ sky130_fd_sc_hd__and2_2
XFILLER_0_48_99 vssd1 vssd1 vccd1 vccd1 sky130_fd_sc_hd__decap_4
X_4131_ _1681_ _1682_ vssd1 vssd1 vccd1 vccd1 _2063_ sky130_fd_sc_hd__or2_1
XFILLER_0_3_35 vccd1 vssd1 vccd1 vssd1 sky130_ef_sc_hd__decap_12
X_4062_ net138 vssd1 vssd1 vccd1 vccd1 _2027_ sky130_fd_sc_hd__clkbuf_1
X_3013_ _0871_ _1464_ _1469_ vssd1 vssd1 vccd1 vccd1 _1471_ sky130_fd_sc_hd__a21oi_4
XFILLER_0_78_416 vssd1 vssd1 vccd1 vccd1 sky130_fd_sc_hd__decap_4
XFILLER_0_19_505 vssd1 vssd1 vccd1 vccd1 sky130_fd_sc_hd__decap_4
Xclkbuf_leaf_16_clk clknet_2_2__leaf_clk vssd1 vssd1 vccd1 vccd1 clknet_leaf_16_clk
+ sky130_fd_sc_hd__clkbuf_16
XFILLER_0_80_53 vccd1 vssd1 vccd1 vssd1 sky130_ef_sc_hd__decap_12
X_3915_ _1953_ vssd1 vssd1 vccd1 vccd1 _0420_ sky130_fd_sc_hd__clkbuf_1
XFILLER_0_80_97 vssd1 vssd1 vccd1 vccd1 sky130_fd_sc_hd__decap_3
XFILLER_0_58_195 vssd1 vssd1 vccd1 vccd1 sky130_fd_sc_hd__fill_1
X_3846_ net222 vssd1 vssd1 vccd1 vccd1 _1919_ sky130_fd_sc_hd__clkbuf_1
XFILLER_0_6_421 vssd1 vssd1 vccd1 vccd1 sky130_fd_sc_hd__fill_2
XFILLER_0_61_305 vssd1 vssd1 vccd1 vccd1 sky130_fd_sc_hd__decap_6
XFILLER_0_80_3 vccd1 vssd1 vccd1 vssd1 sky130_ef_sc_hd__decap_12
X_3777_ _1391_ _1875_ _1353_ _1884_ vssd1 vssd1 vccd1 vccd1 _0351_ sky130_fd_sc_hd__a31o_1
X_2728_ u_core.u_regfile.rf\[29\]\[18\] u_core.u_regfile.rf\[31\]\[18\] _0704_ vssd1
+ vssd1 vccd1 vccd1 _1186_ sky130_fd_sc_hd__mux2_1
X_2659_ _1115_ _0709_ _0802_ _1116_ vssd1 vssd1 vccd1 vccd1 _1117_ sky130_fd_sc_hd__a31o_1
X_4329_ clknet_leaf_2_clk _0140_ vssd1 vssd1 vccd1 vccd1 u_core.u_regfile.rf\[4\]\[29\]
+ sky130_fd_sc_hd__dfxtp_1
XFILLER_0_84_419 vssd1 vssd1 vccd1 vccd1 sky130_fd_sc_hd__fill_1
XFILLER_0_45_390 vssd1 vssd1 vccd1 vccd1 sky130_fd_sc_hd__fill_2
XFILLER_0_20_213 vssd1 vssd1 vccd1 vccd1 sky130_fd_sc_hd__fill_1
XTAP_909 vssd1 vccd1 sky130_fd_sc_hd__tapvpwrvgnd_1
XFILLER_0_75_419 vssd1 vssd1 vccd1 vccd1 sky130_fd_sc_hd__decap_3
XFILLER_0_83_441 vssd1 vssd1 vccd1 vccd1 sky130_fd_sc_hd__decap_6
X_3700_ _1842_ vssd1 vssd1 vccd1 vccd1 _0316_ sky130_fd_sc_hd__clkbuf_1
XFILLER_0_83_485 vccd1 vssd1 vccd1 vssd1 sky130_ef_sc_hd__decap_12
X_4680_ clknet_leaf_34_clk _0481_ vssd1 vssd1 vccd1 vccd1 u_core.u_regfile.rf\[24\]\[18\]
+ sky130_fd_sc_hd__dfxtp_1
X_3631_ net293 vssd1 vssd1 vccd1 vccd1 _1808_ sky130_fd_sc_hd__clkbuf_1
XFILLER_0_70_135 vssd1 vssd1 vccd1 vccd1 sky130_fd_sc_hd__decap_4
X_3562_ net385 vssd1 vssd1 vccd1 vccd1 _1786_ sky130_fd_sc_hd__clkbuf_1
X_2513_ _0700_ _0802_ u_core.u_regfile.rf\[4\]\[10\] vssd1 vssd1 vccd1 vccd1 _0971_
+ sky130_fd_sc_hd__a21o_1
X_3493_ _1683_ _1413_ _1739_ _1480_ _0589_ vssd1 vssd1 vccd1 vccd1 _1751_ sky130_fd_sc_hd__a41o_1
X_2444_ _0901_ u_core.u_regfile.rf\[28\]\[13\] _0697_ vssd1 vssd1 vccd1 vccd1 _0902_
+ sky130_fd_sc_hd__mux2_1
Xclkbuf_leaf_5_clk clknet_2_0__leaf_clk vssd1 vssd1 vccd1 vccd1 clknet_leaf_5_clk
+ sky130_fd_sc_hd__clkbuf_16
X_2375_ _0831_ _0832_ vssd1 vssd1 vccd1 vccd1 _0833_ sky130_fd_sc_hd__nand2_2
X_4114_ net320 vssd1 vssd1 vccd1 vccd1 _2053_ sky130_fd_sc_hd__clkbuf_1
X_4045_ _2018_ vssd1 vssd1 vccd1 vccd1 _0485_ sky130_fd_sc_hd__clkbuf_1
XFILLER_0_74_441 vccd1 vssd1 vccd1 vssd1 sky130_ef_sc_hd__decap_12
XFILLER_0_19_335 vssd1 vssd1 vccd1 vccd1 sky130_fd_sc_hd__fill_1
XFILLER_0_19_346 vssd1 vssd1 vccd1 vccd1 sky130_fd_sc_hd__decap_8
X_3829_ _1910_ vssd1 vssd1 vccd1 vccd1 _0377_ sky130_fd_sc_hd__clkbuf_1
XFILLER_0_61_113 vssd1 vssd1 vccd1 vccd1 sky130_fd_sc_hd__decap_3
XFILLER_0_84_227 vccd1 vssd1 vccd1 vssd1 sky130_ef_sc_hd__decap_12
XFILLER_0_37_121 vssd1 vssd1 vccd1 vccd1 sky130_fd_sc_hd__fill_1
XFILLER_0_80_411 vssd1 vssd1 vccd1 vccd1 sky130_fd_sc_hd__decap_8
XFILLER_0_65_452 vccd1 vssd1 vccd1 vssd1 sky130_ef_sc_hd__decap_12
XFILLER_0_80_433 vccd1 vssd1 vccd1 vssd1 sky130_ef_sc_hd__decap_12
XFILLER_0_20_15 vccd1 vssd1 vccd1 vssd1 sky130_ef_sc_hd__decap_12
XFILLER_0_80_477 vccd1 vssd1 vccd1 vssd1 sky130_ef_sc_hd__decap_12
XFILLER_0_0_405 vccd1 vssd1 vccd1 vssd1 sky130_ef_sc_hd__decap_12
XFILLER_0_0_449 vccd1 vssd1 vccd1 vssd1 sky130_ef_sc_hd__decap_12
XTAP_706 vssd1 vccd1 sky130_fd_sc_hd__tapvpwrvgnd_1
XTAP_717 vssd1 vccd1 sky130_fd_sc_hd__tapvpwrvgnd_1
XTAP_728 vssd1 vccd1 sky130_fd_sc_hd__tapvpwrvgnd_1
XTAP_739 vssd1 vccd1 sky130_fd_sc_hd__tapvpwrvgnd_1
X_2160_ u_timer.count_reg\[15\] _0612_ _0615_ _0618_ vssd1 vssd1 vccd1 vccd1 _0619_
+ sky130_fd_sc_hd__o211ai_1
XFILLER_0_0_69 vccd1 vssd1 vccd1 vssd1 sky130_ef_sc_hd__decap_12
X_2993_ _0967_ _1449_ _1450_ vssd1 vssd1 vccd1 vccd1 _1451_ sky130_fd_sc_hd__nand3_2
X_4801_ clknet_leaf_10_clk _0569_ net21 vssd1 vssd1 vccd1 vccd1 u_audio.sample_reg\[2\]
+ sky130_fd_sc_hd__dfrtp_1
X_4732_ clknet_leaf_13_clk _0533_ net23 vssd1 vssd1 vccd1 vccd1 net9 sky130_fd_sc_hd__dfrtp_1
X_4663_ clknet_leaf_39_clk _0464_ vssd1 vssd1 vccd1 vccd1 u_core.u_regfile.rf\[24\]\[1\]
+ sky130_fd_sc_hd__dfxtp_1
XFILLER_0_43_113 vssd1 vssd1 vccd1 vccd1 sky130_fd_sc_hd__fill_2
XFILLER_0_3_210 vssd1 vssd1 vccd1 vccd1 sky130_fd_sc_hd__fill_1
X_3614_ _1799_ vssd1 vssd1 vccd1 vccd1 _0273_ sky130_fd_sc_hd__clkbuf_1
XFILLER_0_43_146 vccd1 vssd1 vccd1 vssd1 sky130_ef_sc_hd__decap_12
X_4594_ clknet_leaf_35_clk _0395_ vssd1 vssd1 vccd1 vccd1 u_core.u_regfile.rf\[27\]\[28\]
+ sky130_fd_sc_hd__dfxtp_1
X_3545_ _1777_ vssd1 vssd1 vccd1 vccd1 _0226_ sky130_fd_sc_hd__clkbuf_1
X_3476_ _1679_ vssd1 vssd1 vccd1 vccd1 _1741_ sky130_fd_sc_hd__clkbuf_4
X_2427_ _0749_ vssd1 vssd1 vccd1 vccd1 _0885_ sky130_fd_sc_hd__buf_8
XFILLER_0_43_3 vccd1 vssd1 vccd1 vssd1 sky130_ef_sc_hd__decap_12
X_2358_ u_core.u_regfile.rf\[31\]\[26\] _0728_ _0746_ _0716_ _0815_ vssd1 vssd1 vccd1
+ vccd1 _0816_ sky130_fd_sc_hd__o221ai_4
X_2289_ _0704_ _0730_ vssd1 vssd1 vccd1 vccd1 _0747_ sky130_fd_sc_hd__nor2_1
X_4028_ net337 vssd1 vssd1 vccd1 vccd1 _2010_ sky130_fd_sc_hd__clkbuf_1
XFILLER_0_66_238 vssd1 vssd1 vccd1 vccd1 sky130_fd_sc_hd__decap_3
XFILLER_0_34_102 vssd1 vssd1 vccd1 vccd1 sky130_fd_sc_hd__fill_1
XFILLER_0_15_15 vccd1 vssd1 vccd1 vssd1 sky130_ef_sc_hd__decap_12
XFILLER_0_38_452 vssd1 vssd1 vccd1 vccd1 sky130_fd_sc_hd__fill_1
XFILLER_0_65_260 vssd1 vssd1 vccd1 vccd1 sky130_fd_sc_hd__fill_2
XFILLER_0_38_485 vccd1 vssd1 vccd1 vssd1 sky130_ef_sc_hd__decap_12
XFILLER_0_13_308 vssd1 vssd1 vccd1 vccd1 sky130_fd_sc_hd__fill_1
XFILLER_0_13_319 vssd1 vssd1 vccd1 vccd1 sky130_fd_sc_hd__fill_1
Xhold209 u_core.u_regfile.rf\[2\]\[1\] vssd1 vssd1 vccd1 vccd1 net242 sky130_fd_sc_hd__dlygate4sd3_1
X_3330_ net427 vssd1 vssd1 vccd1 vccd1 _1656_ sky130_fd_sc_hd__clkbuf_1
XTAP_503 vssd1 vccd1 sky130_fd_sc_hd__tapvpwrvgnd_1
XTAP_514 vssd1 vccd1 sky130_fd_sc_hd__tapvpwrvgnd_1
XTAP_525 vssd1 vccd1 sky130_fd_sc_hd__tapvpwrvgnd_1
X_3261_ _1626_ _1627_ _1628_ net89 vssd1 vssd1 vccd1 vccd1 _0091_ sky130_fd_sc_hd__o31a_1
XTAP_536 vssd1 vccd1 sky130_fd_sc_hd__tapvpwrvgnd_1
XTAP_547 vssd1 vccd1 sky130_fd_sc_hd__tapvpwrvgnd_1
XTAP_558 vssd1 vccd1 sky130_fd_sc_hd__tapvpwrvgnd_1
X_2212_ _0609_ _0611_ _0660_ _0670_ vssd1 vssd1 vccd1 vccd1 _0671_ sky130_fd_sc_hd__and4b_1
XTAP_569 vssd1 vccd1 sky130_fd_sc_hd__tapvpwrvgnd_1
X_3192_ _1597_ vssd1 vssd1 vccd1 vccd1 _0053_ sky130_fd_sc_hd__clkbuf_1
X_2143_ u_timer.count_reg\[23\] _0601_ vssd1 vssd1 vccd1 vccd1 _0602_ sky130_fd_sc_hd__or2_1
XFILLER_0_72_65 vccd1 vssd1 vccd1 vssd1 sky130_ef_sc_hd__decap_12
XFILLER_0_29_430 vccd1 vssd1 vccd1 vssd1 sky130_ef_sc_hd__decap_12
XFILLER_0_48_238 vssd1 vssd1 vccd1 vccd1 sky130_fd_sc_hd__fill_2
XFILLER_0_8_357 vssd1 vssd1 vccd1 vccd1 sky130_fd_sc_hd__decap_3
X_2976_ _1433_ _1073_ vssd1 vssd1 vccd1 vccd1 _1434_ sky130_fd_sc_hd__xor2_2
X_4715_ clknet_leaf_35_clk _0516_ vssd1 vssd1 vccd1 vccd1 u_core.u_regfile.rf\[25\]\[21\]
+ sky130_fd_sc_hd__dfxtp_1
X_4646_ clknet_leaf_35_clk _0447_ vssd1 vssd1 vccd1 vccd1 u_core.u_regfile.rf\[26\]\[16\]
+ sky130_fd_sc_hd__dfxtp_1
XFILLER_0_21_91 vssd1 vssd1 vccd1 vccd1 sky130_fd_sc_hd__fill_1
XFILLER_0_44_477 vssd1 vssd1 vccd1 vccd1 sky130_fd_sc_hd__decap_4
X_4577_ clknet_leaf_34_clk _0378_ vssd1 vssd1 vccd1 vccd1 u_core.u_regfile.rf\[27\]\[11\]
+ sky130_fd_sc_hd__dfxtp_1
X_3528_ net392 vssd1 vssd1 vccd1 vccd1 _1769_ sky130_fd_sc_hd__clkbuf_1
X_3459_ _1468_ _1704_ _1728_ vssd1 vssd1 vccd1 vccd1 _0189_ sky130_fd_sc_hd__o21ai_1
Xhold92 u_core.u_regfile.rf\[6\]\[8\] vssd1 vssd1 vccd1 vccd1 net125 sky130_fd_sc_hd__dlygate4sd3_1
Xhold81 u_core.u_regfile.rf\[7\]\[24\] vssd1 vssd1 vccd1 vccd1 net114 sky130_fd_sc_hd__dlygate4sd3_1
Xhold70 u_core.u_regfile.rf\[5\]\[24\] vssd1 vssd1 vccd1 vccd1 net103 sky130_fd_sc_hd__dlygate4sd3_1
XFILLER_0_85_333 vssd1 vssd1 vccd1 vccd1 sky130_fd_sc_hd__decap_3
XFILLER_0_85_377 vccd1 vssd1 vccd1 vssd1 sky130_ef_sc_hd__decap_12
X_2830_ _1285_ _1207_ _1286_ _1287_ vssd1 vssd1 vccd1 vccd1 _1288_ sky130_fd_sc_hd__o211ai_1
X_2761_ _0866_ u_core.u_regfile.rf\[1\]\[20\] _0857_ _0867_ vssd1 vssd1 vccd1 vccd1
+ _1219_ sky130_fd_sc_hd__a31o_1
XFILLER_0_26_444 vssd1 vssd1 vccd1 vccd1 sky130_fd_sc_hd__decap_4
XFILLER_0_38_293 vccd1 vssd1 vccd1 vssd1 sky130_ef_sc_hd__decap_12
X_2692_ _1145_ _1147_ _0998_ _1149_ vssd1 vssd1 vccd1 vccd1 _1150_ sky130_fd_sc_hd__nand4_1
XFILLER_0_41_403 vssd1 vssd1 vccd1 vccd1 sky130_fd_sc_hd__decap_6
XFILLER_0_41_425 vssd1 vssd1 vccd1 vccd1 sky130_fd_sc_hd__decap_4
X_4500_ clknet_leaf_24_clk _0301_ vssd1 vssd1 vccd1 vccd1 u_core.u_regfile.rf\[30\]\[30\]
+ sky130_fd_sc_hd__dfxtp_1
XANTENNA_1 net5 vssd1 vssd1 vccd1 vccd1 sky130_fd_sc_hd__diode_2
X_4431_ clknet_leaf_10_clk _0041_ net21 vssd1 vssd1 vccd1 vccd1 u_audio.counter\[2\]
+ sky130_fd_sc_hd__dfrtp_1
X_4362_ clknet_leaf_6_clk _0173_ vssd1 vssd1 vccd1 vccd1 u_core.u_regfile.rf\[5\]\[30\]
+ sky130_fd_sc_hd__dfxtp_1
XTAP_333 vssd1 vccd1 sky130_fd_sc_hd__tapvpwrvgnd_1
XTAP_322 vssd1 vccd1 sky130_fd_sc_hd__tapvpwrvgnd_1
X_3313_ _1647_ vssd1 vssd1 vccd1 vccd1 _0124_ sky130_fd_sc_hd__clkbuf_1
XTAP_311 vssd1 vccd1 sky130_fd_sc_hd__tapvpwrvgnd_1
XTAP_300 vssd1 vccd1 sky130_fd_sc_hd__tapvpwrvgnd_1
X_4293_ clknet_leaf_2_clk _0104_ vssd1 vssd1 vccd1 vccd1 u_core.u_regfile.rf\[6\]\[25\]
+ sky130_fd_sc_hd__dfxtp_1
XTAP_344 vssd1 vccd1 sky130_fd_sc_hd__tapvpwrvgnd_1
X_3244_ _1486_ vssd1 vssd1 vccd1 vccd1 _1624_ sky130_fd_sc_hd__buf_2
XTAP_355 vssd1 vccd1 sky130_fd_sc_hd__tapvpwrvgnd_1
XTAP_366 vssd1 vccd1 sky130_fd_sc_hd__tapvpwrvgnd_1
XTAP_377 vssd1 vccd1 sky130_fd_sc_hd__tapvpwrvgnd_1
XTAP_388 vssd1 vccd1 sky130_fd_sc_hd__tapvpwrvgnd_1
XTAP_399 vssd1 vccd1 sky130_fd_sc_hd__tapvpwrvgnd_1
X_3175_ u_audio.counter\[6\] u_audio.counter\[5\] u_audio.counter\[4\] _1585_ vssd1
+ vssd1 vccd1 vccd1 _1589_ sky130_fd_sc_hd__and4_1
X_2126_ u_timer.count_reg\[24\] vssd1 vssd1 vccd1 vccd1 _0585_ sky130_fd_sc_hd__inv_2
XPHY_28 vssd1 vssd1 vccd1 vccd1 sky130_fd_sc_hd__decap_3
XPHY_17 vssd1 vssd1 vccd1 vccd1 sky130_fd_sc_hd__decap_3
XFILLER_0_49_503 vssd1 vssd1 vccd1 vccd1 sky130_fd_sc_hd__fill_1
XPHY_39 vssd1 vssd1 vccd1 vccd1 sky130_fd_sc_hd__decap_3
XFILLER_0_17_444 vssd1 vssd1 vccd1 vccd1 sky130_fd_sc_hd__fill_1
X_2959_ u_audio.s_axi_bvalid _1416_ vssd1 vssd1 vccd1 vccd1 _1417_ sky130_fd_sc_hd__or2_1
XFILLER_0_17_488 vccd1 vssd1 vccd1 vssd1 sky130_ef_sc_hd__decap_12
XFILLER_0_44_274 vssd1 vssd1 vccd1 vccd1 sky130_fd_sc_hd__fill_1
XFILLER_0_4_371 vssd1 vssd1 vccd1 vccd1 sky130_fd_sc_hd__decap_4
X_4629_ clknet_leaf_7_clk _0430_ vssd1 vssd1 vccd1 vccd1 u_core.u_regfile.rf\[1\]\[31\]
+ sky130_fd_sc_hd__dfxtp_1
XFILLER_0_12_27 vssd1 vssd1 vccd1 vccd1 sky130_fd_sc_hd__fill_1
XFILLER_0_70_509 vssd1 vssd1 vccd1 vccd1 sky130_fd_sc_hd__fill_1
XFILLER_0_35_230 vssd1 vssd1 vccd1 vccd1 sky130_fd_sc_hd__fill_2
XFILLER_0_50_244 vssd1 vssd1 vccd1 vccd1 sky130_fd_sc_hd__fill_1
Xoutput3 net3 vssd1 vssd1 vccd1 vccd1 gpio_pins[0] sky130_fd_sc_hd__clkbuf_4
XFILLER_0_85_141 vccd1 vssd1 vccd1 vssd1 sky130_ef_sc_hd__decap_12
X_3931_ _1961_ vssd1 vssd1 vccd1 vccd1 _0428_ sky130_fd_sc_hd__clkbuf_1
XFILLER_0_53_89 vssd1 vssd1 vccd1 vccd1 sky130_fd_sc_hd__fill_1
X_3862_ net321 vssd1 vssd1 vccd1 vccd1 _1927_ sky130_fd_sc_hd__clkbuf_1
XFILLER_0_26_230 vssd1 vssd1 vccd1 vccd1 sky130_fd_sc_hd__decap_3
X_2813_ _1268_ _1270_ vssd1 vssd1 vccd1 vccd1 _1271_ sky130_fd_sc_hd__nor2_1
XFILLER_0_61_509 vssd1 vssd1 vccd1 vccd1 sky130_fd_sc_hd__fill_1
XFILLER_0_14_403 vssd1 vssd1 vccd1 vccd1 sky130_fd_sc_hd__fill_1
XFILLER_0_5_113 vssd1 vssd1 vccd1 vccd1 sky130_fd_sc_hd__fill_2
X_3793_ _1393_ _1394_ _1875_ _1892_ vssd1 vssd1 vccd1 vccd1 _0359_ sky130_fd_sc_hd__a31o_1
XFILLER_0_81_380 vccd1 vssd1 vccd1 vssd1 sky130_ef_sc_hd__decap_12
X_2744_ _1200_ _0696_ _0733_ _0903_ _1201_ vssd1 vssd1 vccd1 vccd1 _1202_ sky130_fd_sc_hd__o221ai_4
X_2675_ _0874_ vssd1 vssd1 vccd1 vccd1 _1133_ sky130_fd_sc_hd__buf_2
XFILLER_0_78_53 vccd1 vssd1 vccd1 vssd1 sky130_ef_sc_hd__decap_12
X_4414_ clknet_leaf_41_clk _0225_ vssd1 vssd1 vccd1 vccd1 u_core.u_regfile.rf\[29\]\[18\]
+ sky130_fd_sc_hd__dfxtp_1
XFILLER_0_78_97 vccd1 vssd1 vccd1 vssd1 sky130_ef_sc_hd__decap_12
XFILLER_0_1_385 vssd1 vssd1 vccd1 vccd1 sky130_fd_sc_hd__decap_6
X_4345_ clknet_leaf_31_clk _0156_ vssd1 vssd1 vccd1 vccd1 u_core.u_regfile.rf\[5\]\[13\]
+ sky130_fd_sc_hd__dfxtp_1
X_4276_ clknet_leaf_49_clk _0087_ vssd1 vssd1 vccd1 vccd1 u_core.u_regfile.rf\[6\]\[8\]
+ sky130_fd_sc_hd__dfxtp_1
XTAP_174 vssd1 vccd1 sky130_fd_sc_hd__tapvpwrvgnd_1
XTAP_185 vssd1 vccd1 sky130_fd_sc_hd__tapvpwrvgnd_1
XTAP_196 vssd1 vccd1 sky130_fd_sc_hd__tapvpwrvgnd_1
X_3227_ u_core.u_regfile.rf\[31\]\[24\] vssd1 vssd1 vccd1 vccd1 _1615_ sky130_fd_sc_hd__clkbuf_1
X_3158_ u_audio.counter\[6\] _1577_ vssd1 vssd1 vccd1 vccd1 _1579_ sky130_fd_sc_hd__or2_1
X_3089_ _1527_ vssd1 vssd1 vccd1 vccd1 _0012_ sky130_fd_sc_hd__clkbuf_1
XFILLER_0_76_141 vccd1 vssd1 vccd1 vssd1 sky130_ef_sc_hd__decap_12
XFILLER_0_9_441 vssd1 vssd1 vccd1 vccd1 sky130_fd_sc_hd__decap_6
XFILLER_0_9_430 vssd1 vssd1 vccd1 vccd1 sky130_fd_sc_hd__decap_3
XFILLER_0_9_474 vccd1 vssd1 vccd1 vssd1 sky130_ef_sc_hd__decap_12
XFILLER_0_52_509 vssd1 vssd1 vccd1 vccd1 sky130_fd_sc_hd__fill_1
XFILLER_0_17_241 vssd1 vssd1 vccd1 vccd1 sky130_fd_sc_hd__decap_3
Xhold370 u_core.u_regfile.rf\[1\]\[20\] vssd1 vssd1 vccd1 vccd1 net403 sky130_fd_sc_hd__dlygate4sd3_1
Xhold381 u_core.u_regfile.rf\[29\]\[19\] vssd1 vssd1 vccd1 vccd1 net414 sky130_fd_sc_hd__dlygate4sd3_1
Xhold392 u_core.u_regfile.rf\[4\]\[17\] vssd1 vssd1 vccd1 vccd1 net425 sky130_fd_sc_hd__dlygate4sd3_1
XFILLER_0_23_15 vssd1 vssd1 vccd1 vccd1 sky130_fd_sc_hd__decap_6
XFILLER_0_63_391 vssd1 vssd1 vccd1 vccd1 sky130_fd_sc_hd__fill_1
X_2460_ _0917_ _0916_ _0906_ vssd1 vssd1 vccd1 vccd1 _0918_ sky130_fd_sc_hd__o21ai_1
XFILLER_0_48_45 vssd1 vssd1 vccd1 vccd1 sky130_fd_sc_hd__fill_1
X_2391_ _0799_ _0712_ _0717_ _0707_ _0806_ vssd1 vssd1 vccd1 vccd1 _0849_ sky130_fd_sc_hd__a41o_1
X_4130_ _2061_ _1705_ _1686_ vssd1 vssd1 vccd1 vccd1 _2062_ sky130_fd_sc_hd__nand3b_4
XFILLER_0_48_78 vssd1 vssd1 vccd1 vccd1 sky130_fd_sc_hd__decap_6
X_4061_ _2026_ vssd1 vssd1 vccd1 vccd1 _0493_ sky130_fd_sc_hd__clkbuf_1
XFILLER_0_3_47 vssd1 vssd1 vccd1 vccd1 sky130_fd_sc_hd__decap_8
X_3012_ _0782_ _0856_ _1468_ _1464_ _1469_ vssd1 vssd1 vccd1 vccd1 _1470_ sky130_fd_sc_hd__o311a_2
Xwire15 _2060_ vssd1 vssd1 vccd1 vccd1 net15 sky130_fd_sc_hd__buf_1
XFILLER_0_80_65 vccd1 vssd1 vccd1 vssd1 sky130_ef_sc_hd__decap_12
X_3914_ net477 vssd1 vssd1 vccd1 vccd1 _1953_ sky130_fd_sc_hd__clkbuf_1
X_3845_ _1918_ vssd1 vssd1 vccd1 vccd1 _0385_ sky130_fd_sc_hd__clkbuf_1
X_3776_ _1876_ _1877_ net464 vssd1 vssd1 vccd1 vccd1 _1884_ sky130_fd_sc_hd__o21a_1
X_2727_ _1179_ _1183_ _1184_ vssd1 vssd1 vccd1 vccd1 _1185_ sky130_fd_sc_hd__o21a_2
XFILLER_0_73_3 vccd1 vssd1 vccd1 vssd1 sky130_ef_sc_hd__decap_12
X_2658_ _0730_ _0740_ u_core.u_regfile.rf\[28\]\[7\] vssd1 vssd1 vccd1 vccd1 _1116_
+ sky130_fd_sc_hd__o21a_1
X_2589_ _1044_ _0693_ _1045_ _1046_ vssd1 vssd1 vccd1 vccd1 _1047_ sky130_fd_sc_hd__a211oi_2
X_4328_ clknet_leaf_2_clk _0139_ vssd1 vssd1 vccd1 vccd1 u_core.u_regfile.rf\[4\]\[28\]
+ sky130_fd_sc_hd__dfxtp_1
X_4259_ clknet_leaf_6_clk _0074_ vssd1 vssd1 vccd1 vccd1 u_core.u_regfile.rf\[31\]\[27\]
+ sky130_fd_sc_hd__dfxtp_1
XFILLER_0_69_428 vssd1 vssd1 vccd1 vccd1 sky130_fd_sc_hd__fill_1
XFILLER_0_37_303 vssd1 vssd1 vccd1 vccd1 sky130_fd_sc_hd__decap_8
XFILLER_0_49_196 vssd1 vssd1 vccd1 vccd1 sky130_fd_sc_hd__decap_3
XFILLER_0_25_509 vssd1 vssd1 vccd1 vccd1 sky130_fd_sc_hd__fill_1
XFILLER_0_18_15 vccd1 vssd1 vccd1 vssd1 sky130_ef_sc_hd__decap_12
XFILLER_0_28_347 vssd1 vssd1 vccd1 vccd1 sky130_fd_sc_hd__fill_1
XFILLER_0_83_497 vssd1 vssd1 vccd1 vccd1 sky130_fd_sc_hd__decap_6
X_3630_ _1807_ vssd1 vssd1 vccd1 vccd1 _0281_ sky130_fd_sc_hd__clkbuf_1
X_3561_ _1785_ vssd1 vssd1 vccd1 vccd1 _0234_ sky130_fd_sc_hd__clkbuf_1
X_2512_ _0968_ _0969_ _0750_ vssd1 vssd1 vccd1 vccd1 _0970_ sky130_fd_sc_hd__nand3_2
XFILLER_0_3_447 vssd1 vssd1 vccd1 vccd1 sky130_fd_sc_hd__fill_1
XFILLER_0_59_77 vccd1 vssd1 vccd1 vssd1 sky130_ef_sc_hd__decap_12
X_3492_ _1736_ _1749_ _1750_ vssd1 vssd1 vccd1 vccd1 _0200_ sky130_fd_sc_hd__o21ai_1
X_2443_ u_core.u_regfile.rf\[29\]\[13\] u_core.u_regfile.rf\[31\]\[13\] _0840_ vssd1
+ vssd1 vccd1 vccd1 _0901_ sky130_fd_sc_hd__mux2_1
X_2374_ _0826_ _0772_ _0707_ _0830_ vssd1 vssd1 vccd1 vccd1 _0832_ sky130_fd_sc_hd__a31o_1
X_4113_ _2052_ vssd1 vssd1 vccd1 vccd1 _0519_ sky130_fd_sc_hd__clkbuf_1
X_4044_ net279 vssd1 vssd1 vccd1 vccd1 _2018_ sky130_fd_sc_hd__clkbuf_1
XFILLER_0_74_431 vssd1 vssd1 vccd1 vccd1 sky130_fd_sc_hd__decap_6
XFILLER_0_74_475 vssd1 vssd1 vccd1 vccd1 sky130_fd_sc_hd__fill_1
XFILLER_0_74_464 vssd1 vssd1 vccd1 vccd1 sky130_fd_sc_hd__fill_1
XFILLER_0_74_453 vssd1 vssd1 vccd1 vccd1 sky130_fd_sc_hd__decap_8
X_3828_ net163 vssd1 vssd1 vccd1 vccd1 _1910_ sky130_fd_sc_hd__clkbuf_1
XFILLER_0_34_328 vssd1 vssd1 vccd1 vccd1 sky130_fd_sc_hd__fill_1
X_3759_ _1416_ net522 _1868_ vssd1 vssd1 vccd1 vccd1 _1874_ sky130_fd_sc_hd__mux2_1
XFILLER_0_42_361 vssd1 vssd1 vccd1 vccd1 sky130_fd_sc_hd__decap_3
XFILLER_0_84_239 vssd1 vssd1 vccd1 vccd1 sky130_fd_sc_hd__fill_1
XFILLER_0_65_420 vssd1 vssd1 vccd1 vccd1 sky130_fd_sc_hd__fill_1
XFILLER_0_65_464 vccd1 vssd1 vccd1 vssd1 sky130_ef_sc_hd__decap_12
XFILLER_0_37_177 vssd1 vssd1 vccd1 vccd1 sky130_fd_sc_hd__fill_2
XFILLER_0_80_445 vccd1 vssd1 vccd1 vssd1 sky130_ef_sc_hd__decap_12
XFILLER_0_20_27 vssd1 vssd1 vccd1 vccd1 sky130_fd_sc_hd__fill_1
XFILLER_0_20_49 vssd1 vssd1 vccd1 vccd1 sky130_fd_sc_hd__fill_1
XFILLER_0_40_309 vssd1 vssd1 vccd1 vccd1 sky130_fd_sc_hd__decap_3
XFILLER_0_80_489 vccd1 vssd1 vccd1 vssd1 sky130_ef_sc_hd__decap_12
XFILLER_0_0_417 vssd1 vssd1 vccd1 vccd1 sky130_fd_sc_hd__decap_3
XTAP_707 vssd1 vccd1 sky130_fd_sc_hd__tapvpwrvgnd_1
XTAP_718 vssd1 vccd1 sky130_fd_sc_hd__tapvpwrvgnd_1
XTAP_729 vssd1 vccd1 sky130_fd_sc_hd__tapvpwrvgnd_1
X_4800_ clknet_leaf_10_clk _0568_ net21 vssd1 vssd1 vccd1 vccd1 u_audio.sample_reg\[1\]
+ sky130_fd_sc_hd__dfrtp_1
X_2992_ _1415_ _1147_ vssd1 vssd1 vccd1 vccd1 _1450_ sky130_fd_sc_hd__nand2_1
X_4731_ clknet_leaf_6_clk _0532_ net23 vssd1 vssd1 vccd1 vccd1 net8 sky130_fd_sc_hd__dfrtp_2
X_4662_ clknet_leaf_37_clk _0463_ vssd1 vssd1 vccd1 vccd1 u_core.u_regfile.rf\[24\]\[0\]
+ sky130_fd_sc_hd__dfxtp_1
XFILLER_0_9_57 vssd1 vssd1 vccd1 vccd1 sky130_fd_sc_hd__fill_2
X_3613_ net244 vssd1 vssd1 vccd1 vccd1 _1799_ sky130_fd_sc_hd__clkbuf_1
XFILLER_0_43_158 vssd1 vssd1 vccd1 vccd1 sky130_fd_sc_hd__decap_8
XFILLER_0_3_222 vssd1 vssd1 vccd1 vccd1 sky130_fd_sc_hd__fill_2
XFILLER_0_24_361 vssd1 vssd1 vccd1 vccd1 sky130_fd_sc_hd__decap_3
X_4593_ clknet_leaf_34_clk _0394_ vssd1 vssd1 vccd1 vccd1 u_core.u_regfile.rf\[27\]\[27\]
+ sky130_fd_sc_hd__dfxtp_1
XFILLER_0_3_277 vssd1 vssd1 vccd1 vccd1 sky130_fd_sc_hd__decap_3
X_3544_ net414 vssd1 vssd1 vccd1 vccd1 _1777_ sky130_fd_sc_hd__clkbuf_1
XFILLER_0_10_93 vssd1 vssd1 vccd1 vccd1 sky130_fd_sc_hd__fill_1
X_3475_ _1736_ _1738_ _1740_ vssd1 vssd1 vccd1 vccd1 _0193_ sky130_fd_sc_hd__o21ai_1
X_2426_ _0879_ u_core.u_regfile.rf\[5\]\[12\] _0724_ _0883_ vssd1 vssd1 vccd1 vccd1
+ _0884_ sky130_fd_sc_hd__o211ai_2
XFILLER_0_36_3 vssd1 vssd1 vccd1 vccd1 sky130_fd_sc_hd__decap_8
X_2357_ _0716_ _0741_ u_core.u_regfile.rf\[1\]\[26\] _0743_ _0814_ vssd1 vssd1 vccd1
+ vccd1 _0815_ sky130_fd_sc_hd__a221o_1
X_2288_ _0745_ vssd1 vssd1 vccd1 vccd1 _0746_ sky130_fd_sc_hd__buf_6
X_4027_ _2009_ vssd1 vssd1 vccd1 vccd1 _0476_ sky130_fd_sc_hd__clkbuf_1
XFILLER_0_19_100 vssd1 vssd1 vccd1 vccd1 sky130_fd_sc_hd__fill_1
XFILLER_0_47_442 vssd1 vssd1 vccd1 vccd1 sky130_fd_sc_hd__decap_6
XFILLER_0_30_397 vssd1 vssd1 vccd1 vccd1 sky130_fd_sc_hd__decap_6
XFILLER_0_15_27 vssd1 vssd1 vccd1 vccd1 sky130_fd_sc_hd__fill_2
XFILLER_0_57_239 vssd1 vssd1 vccd1 vccd1 sky130_fd_sc_hd__fill_1
XFILLER_0_5_509 vssd1 vssd1 vccd1 vccd1 sky130_fd_sc_hd__fill_1
XFILLER_0_31_37 vssd1 vssd1 vccd1 vccd1 sky130_fd_sc_hd__decap_3
XFILLER_0_38_475 vssd1 vssd1 vccd1 vccd1 sky130_fd_sc_hd__fill_1
XFILLER_0_38_497 vccd1 vssd1 vccd1 vssd1 sky130_ef_sc_hd__decap_12
XFILLER_0_80_253 vssd1 vssd1 vccd1 vccd1 sky130_fd_sc_hd__decap_3
XFILLER_0_80_264 vssd1 vssd1 vccd1 vccd1 sky130_fd_sc_hd__decap_3
XFILLER_0_0_225 vccd1 vssd1 vccd1 vssd1 sky130_ef_sc_hd__decap_12
XTAP_504 vssd1 vccd1 sky130_fd_sc_hd__tapvpwrvgnd_1
XTAP_515 vssd1 vccd1 sky130_fd_sc_hd__tapvpwrvgnd_1
X_3260_ _1626_ _1627_ _1628_ net121 vssd1 vssd1 vccd1 vccd1 _0090_ sky130_fd_sc_hd__o31a_1
XTAP_526 vssd1 vccd1 sky130_fd_sc_hd__tapvpwrvgnd_1
XTAP_537 vssd1 vccd1 sky130_fd_sc_hd__tapvpwrvgnd_1
XTAP_548 vssd1 vccd1 sky130_fd_sc_hd__tapvpwrvgnd_1
X_2211_ _0662_ _0665_ _0669_ vssd1 vssd1 vccd1 vccd1 _0670_ sky130_fd_sc_hd__and3_1
XTAP_559 vssd1 vccd1 sky130_fd_sc_hd__tapvpwrvgnd_1
X_3191_ net487 vssd1 vssd1 vccd1 vccd1 _1597_ sky130_fd_sc_hd__clkbuf_1
X_2142_ net552 vssd1 vssd1 vccd1 vccd1 _0601_ sky130_fd_sc_hd__inv_2
XFILLER_0_72_77 vssd1 vssd1 vccd1 vccd1 sky130_fd_sc_hd__decap_6
XFILLER_0_29_442 vssd1 vssd1 vccd1 vccd1 sky130_fd_sc_hd__decap_6
XFILLER_0_29_464 vssd1 vssd1 vccd1 vccd1 sky130_fd_sc_hd__fill_2
X_4714_ clknet_leaf_36_clk _0515_ vssd1 vssd1 vccd1 vccd1 u_core.u_regfile.rf\[25\]\[20\]
+ sky130_fd_sc_hd__dfxtp_1
XFILLER_0_29_486 vssd1 vssd1 vccd1 vccd1 sky130_fd_sc_hd__fill_1
X_2975_ _1100_ _1101_ vssd1 vssd1 vccd1 vccd1 _1433_ sky130_fd_sc_hd__nand2_1
XFILLER_0_56_294 vssd1 vssd1 vccd1 vccd1 sky130_fd_sc_hd__decap_6
X_4645_ clknet_leaf_35_clk _0446_ vssd1 vssd1 vccd1 vccd1 u_core.u_regfile.rf\[26\]\[15\]
+ sky130_fd_sc_hd__dfxtp_1
X_4576_ clknet_leaf_34_clk _0377_ vssd1 vssd1 vccd1 vccd1 u_core.u_regfile.rf\[27\]\[10\]
+ sky130_fd_sc_hd__dfxtp_1
XFILLER_0_12_342 vccd1 vssd1 vccd1 vssd1 sky130_ef_sc_hd__decap_12
X_3527_ _1768_ vssd1 vssd1 vccd1 vccd1 _0217_ sky130_fd_sc_hd__clkbuf_1
X_3458_ _1705_ _1725_ _1714_ _1726_ _0616_ vssd1 vssd1 vccd1 vccd1 _1728_ sky130_fd_sc_hd__a41o_1
X_2409_ _0690_ vssd1 vssd1 vccd1 vccd1 _0867_ sky130_fd_sc_hd__clkbuf_4
X_3389_ _1405_ _1674_ _0898_ net58 vssd1 vssd1 vccd1 vccd1 _0173_ sky130_fd_sc_hd__o31a_1
XFILLER_0_79_331 vssd1 vssd1 vccd1 vccd1 sky130_fd_sc_hd__fill_2
XFILLER_0_54_209 vssd1 vssd1 vccd1 vccd1 sky130_fd_sc_hd__decap_4
XFILLER_0_47_272 vssd1 vssd1 vccd1 vccd1 sky130_fd_sc_hd__fill_2
XFILLER_0_7_391 vssd1 vssd1 vccd1 vccd1 sky130_fd_sc_hd__fill_1
XFILLER_0_35_489 vssd1 vssd1 vccd1 vccd1 sky130_fd_sc_hd__fill_1
XFILLER_0_62_253 vssd1 vssd1 vccd1 vccd1 sky130_fd_sc_hd__decap_3
Xhold71 u_core.u_regfile.rf\[7\]\[5\] vssd1 vssd1 vccd1 vccd1 net104 sky130_fd_sc_hd__dlygate4sd3_1
Xhold60 u_core.u_regfile.rf\[7\]\[12\] vssd1 vssd1 vccd1 vccd1 net93 sky130_fd_sc_hd__dlygate4sd3_1
Xhold82 u_core.u_regfile.rf\[6\]\[23\] vssd1 vssd1 vccd1 vccd1 net115 sky130_fd_sc_hd__dlygate4sd3_1
Xhold93 u_core.u_regfile.rf\[6\]\[9\] vssd1 vssd1 vccd1 vccd1 net126 sky130_fd_sc_hd__dlygate4sd3_1
XFILLER_0_58_504 vssd1 vssd1 vccd1 vccd1 sky130_fd_sc_hd__decap_6
XFILLER_0_85_389 vssd1 vssd1 vccd1 vccd1 sky130_fd_sc_hd__decap_3
X_2760_ _0700_ _0939_ u_core.u_regfile.rf\[4\]\[20\] vssd1 vssd1 vccd1 vccd1 _1218_
+ sky130_fd_sc_hd__a21o_1
XFILLER_0_53_242 vssd1 vssd1 vccd1 vccd1 sky130_fd_sc_hd__fill_2
X_2691_ _0981_ _0982_ _1148_ _0984_ vssd1 vssd1 vccd1 vccd1 _1149_ sky130_fd_sc_hd__o31a_1
X_4430_ clknet_leaf_10_clk net35 net26 vssd1 vssd1 vccd1 vccd1 u_audio.counter\[1\]
+ sky130_fd_sc_hd__dfrtp_2
X_4361_ clknet_leaf_18_clk _0172_ vssd1 vssd1 vccd1 vccd1 u_core.u_regfile.rf\[5\]\[29\]
+ sky130_fd_sc_hd__dfxtp_1
X_3312_ net460 vssd1 vssd1 vccd1 vccd1 _1647_ sky130_fd_sc_hd__clkbuf_1
XTAP_323 vssd1 vccd1 sky130_fd_sc_hd__tapvpwrvgnd_1
XTAP_312 vssd1 vccd1 sky130_fd_sc_hd__tapvpwrvgnd_1
XTAP_301 vssd1 vccd1 sky130_fd_sc_hd__tapvpwrvgnd_1
X_4292_ clknet_leaf_2_clk _0103_ vssd1 vssd1 vccd1 vccd1 u_core.u_regfile.rf\[6\]\[24\]
+ sky130_fd_sc_hd__dfxtp_1
XTAP_345 vssd1 vccd1 sky130_fd_sc_hd__tapvpwrvgnd_1
XTAP_334 vssd1 vccd1 sky130_fd_sc_hd__tapvpwrvgnd_1
X_3243_ _1487_ vssd1 vssd1 vccd1 vccd1 _1623_ sky130_fd_sc_hd__buf_2
XTAP_356 vssd1 vccd1 sky130_fd_sc_hd__tapvpwrvgnd_1
XTAP_367 vssd1 vccd1 sky130_fd_sc_hd__tapvpwrvgnd_1
XTAP_378 vssd1 vccd1 sky130_fd_sc_hd__tapvpwrvgnd_1
XTAP_389 vssd1 vccd1 sky130_fd_sc_hd__tapvpwrvgnd_1
X_3174_ _1587_ _1588_ vssd1 vssd1 vccd1 vccd1 _0044_ sky130_fd_sc_hd__nor2_1
X_2125_ net540 vssd1 vssd1 vccd1 vccd1 _0584_ sky130_fd_sc_hd__inv_2
XPHY_29 vssd1 vssd1 vccd1 vccd1 sky130_fd_sc_hd__decap_3
XPHY_18 vssd1 vssd1 vccd1 vccd1 sky130_fd_sc_hd__decap_3
XFILLER_0_16_92 vssd1 vssd1 vccd1 vccd1 sky130_fd_sc_hd__fill_2
X_2958_ _1147_ _1415_ vssd1 vssd1 vccd1 vccd1 _1416_ sky130_fd_sc_hd__xor2_4
XFILLER_0_32_91 vssd1 vssd1 vccd1 vccd1 sky130_fd_sc_hd__fill_1
X_2889_ _1346_ _1249_ _1246_ vssd1 vssd1 vccd1 vccd1 _1347_ sky130_fd_sc_hd__and3_1
X_4628_ clknet_leaf_9_clk _0429_ vssd1 vssd1 vccd1 vccd1 u_core.u_regfile.rf\[1\]\[30\]
+ sky130_fd_sc_hd__dfxtp_1
Xhold530 u_timer.count_reg\[21\] vssd1 vssd1 vccd1 vccd1 net563 sky130_fd_sc_hd__dlygate4sd3_1
X_4559_ clknet_leaf_19_clk _0360_ vssd1 vssd1 vccd1 vccd1 u_core.u_regfile.rf\[28\]\[25\]
+ sky130_fd_sc_hd__dfxtp_1
XTAP_890 vssd1 vccd1 sky130_fd_sc_hd__tapvpwrvgnd_1
XFILLER_0_67_334 vssd1 vssd1 vccd1 vccd1 sky130_fd_sc_hd__fill_2
XFILLER_0_2_309 vccd1 vssd1 vccd1 vssd1 sky130_ef_sc_hd__decap_12
Xoutput4 net4 vssd1 vssd1 vccd1 vccd1 gpio_pins[1] sky130_fd_sc_hd__clkbuf_4
X_3930_ net440 vssd1 vssd1 vccd1 vccd1 _1961_ sky130_fd_sc_hd__clkbuf_1
XFILLER_0_53_57 vssd1 vssd1 vccd1 vccd1 sky130_fd_sc_hd__decap_8
XFILLER_0_85_153 vccd1 vssd1 vccd1 vssd1 sky130_ef_sc_hd__decap_12
X_3861_ _1926_ vssd1 vssd1 vccd1 vccd1 _0393_ sky130_fd_sc_hd__clkbuf_1
XFILLER_0_85_197 vccd1 vssd1 vccd1 vssd1 sky130_ef_sc_hd__decap_12
X_2812_ _1269_ _1267_ _1262_ _0735_ vssd1 vssd1 vccd1 vccd1 _1270_ sky130_fd_sc_hd__and4b_2
X_3792_ _1484_ _1877_ net496 vssd1 vssd1 vccd1 vccd1 _1892_ sky130_fd_sc_hd__o21a_1
X_2743_ _0922_ _0954_ u_core.u_regfile.rf\[28\]\[17\] vssd1 vssd1 vccd1 vccd1 _1201_
+ sky130_fd_sc_hd__o21ai_2
XFILLER_0_14_415 vssd1 vssd1 vccd1 vccd1 sky130_fd_sc_hd__fill_2
XFILLER_0_5_147 vssd1 vssd1 vccd1 vccd1 sky130_fd_sc_hd__decap_4
X_2674_ _0900_ _1117_ _1118_ _0724_ vssd1 vssd1 vccd1 vccd1 _1132_ sky130_fd_sc_hd__o211ai_2
XFILLER_0_78_65 vccd1 vssd1 vccd1 vssd1 sky130_ef_sc_hd__decap_12
X_4413_ clknet_leaf_45_clk _0224_ vssd1 vssd1 vccd1 vccd1 u_core.u_regfile.rf\[29\]\[17\]
+ sky130_fd_sc_hd__dfxtp_1
X_4344_ clknet_leaf_30_clk _0155_ vssd1 vssd1 vccd1 vccd1 u_core.u_regfile.rf\[5\]\[12\]
+ sky130_fd_sc_hd__dfxtp_2
X_4275_ clknet_leaf_49_clk _0086_ vssd1 vssd1 vccd1 vccd1 u_core.u_regfile.rf\[6\]\[7\]
+ sky130_fd_sc_hd__dfxtp_1
XTAP_175 vssd1 vccd1 sky130_fd_sc_hd__tapvpwrvgnd_1
XTAP_186 vssd1 vccd1 sky130_fd_sc_hd__tapvpwrvgnd_1
XTAP_197 vssd1 vccd1 sky130_fd_sc_hd__tapvpwrvgnd_1
X_3226_ _1614_ vssd1 vssd1 vccd1 vccd1 _0070_ sky130_fd_sc_hd__clkbuf_1
X_3157_ _1577_ u_audio.counter\[6\] vssd1 vssd1 vccd1 vccd1 _1578_ sky130_fd_sc_hd__nand2_1
X_3088_ _1525_ _1495_ _1526_ vssd1 vssd1 vccd1 vccd1 _1527_ sky130_fd_sc_hd__and3b_1
XFILLER_0_76_153 vssd1 vssd1 vccd1 vccd1 sky130_fd_sc_hd__decap_3
XFILLER_0_9_486 vccd1 vssd1 vccd1 vssd1 sky130_ef_sc_hd__decap_12
XFILLER_0_17_275 vssd1 vssd1 vccd1 vccd1 sky130_fd_sc_hd__decap_4
Xhold371 u_core.u_regfile.rf\[1\]\[8\] vssd1 vssd1 vccd1 vccd1 net404 sky130_fd_sc_hd__dlygate4sd3_1
Xhold360 u_core.u_regfile.rf\[1\]\[4\] vssd1 vssd1 vccd1 vccd1 net393 sky130_fd_sc_hd__dlygate4sd3_1
Xhold393 u_core.u_regfile.rf\[4\]\[8\] vssd1 vssd1 vccd1 vccd1 net426 sky130_fd_sc_hd__dlygate4sd3_1
Xhold382 u_audio.counter\[4\] vssd1 vssd1 vccd1 vccd1 net415 sky130_fd_sc_hd__dlygate4sd3_1
XFILLER_0_59_109 vssd1 vssd1 vccd1 vccd1 sky130_fd_sc_hd__decap_3
XFILLER_0_70_307 vssd1 vssd1 vccd1 vccd1 sky130_fd_sc_hd__fill_1
XFILLER_0_11_407 vssd1 vssd1 vccd1 vccd1 sky130_fd_sc_hd__fill_1
X_2390_ _0781_ _0816_ _0820_ vssd1 vssd1 vccd1 vccd1 _0848_ sky130_fd_sc_hd__o21bai_1
XFILLER_0_48_68 vssd1 vssd1 vccd1 vccd1 sky130_fd_sc_hd__fill_1
XFILLER_0_3_15 vssd1 vssd1 vccd1 vccd1 sky130_fd_sc_hd__decap_4
X_4060_ net172 vssd1 vssd1 vccd1 vccd1 _2026_ sky130_fd_sc_hd__clkbuf_1
X_3011_ _0920_ _0927_ _0932_ _0934_ vssd1 vssd1 vccd1 vccd1 _1469_ sky130_fd_sc_hd__o31a_1
XFILLER_0_64_67 vccd1 vssd1 vccd1 vssd1 sky130_ef_sc_hd__decap_12
XFILLER_0_73_101 vssd1 vssd1 vccd1 vccd1 sky130_fd_sc_hd__decap_3
X_3913_ _1952_ vssd1 vssd1 vccd1 vccd1 _0419_ sky130_fd_sc_hd__clkbuf_1
XFILLER_0_58_153 vssd1 vssd1 vccd1 vccd1 sky130_fd_sc_hd__decap_3
XFILLER_0_80_77 vssd1 vssd1 vccd1 vccd1 sky130_fd_sc_hd__decap_6
XFILLER_0_73_134 vssd1 vssd1 vccd1 vccd1 sky130_fd_sc_hd__fill_2
X_3844_ net192 vssd1 vssd1 vccd1 vccd1 _1918_ sky130_fd_sc_hd__clkbuf_1
XFILLER_0_58_197 vccd1 vssd1 vccd1 vssd1 sky130_ef_sc_hd__decap_12
X_3775_ _1883_ vssd1 vssd1 vccd1 vccd1 _0350_ sky130_fd_sc_hd__clkbuf_1
X_2726_ u_core.u_regfile.rf\[31\]\[18\] _0726_ _0745_ _0803_ vssd1 vssd1 vccd1 vccd1
+ _1184_ sky130_fd_sc_hd__o22a_1
XFILLER_0_14_289 vssd1 vssd1 vccd1 vccd1 sky130_fd_sc_hd__fill_1
X_2657_ u_core.u_regfile.rf\[29\]\[7\] u_core.u_regfile.rf\[31\]\[7\] _0704_ vssd1
+ vssd1 vccd1 vccd1 _1115_ sky130_fd_sc_hd__mux2_1
XFILLER_0_66_3 vccd1 vssd1 vccd1 vssd1 sky130_ef_sc_hd__decap_12
XFILLER_0_1_172 vccd1 vssd1 vccd1 vssd1 sky130_ef_sc_hd__decap_12
X_2588_ u_core.u_regfile.rf\[5\]\[1\] _0733_ _0904_ vssd1 vssd1 vccd1 vccd1 _1046_
+ sky130_fd_sc_hd__nor3_1
X_4327_ clknet_leaf_2_clk _0138_ vssd1 vssd1 vccd1 vccd1 u_core.u_regfile.rf\[4\]\[27\]
+ sky130_fd_sc_hd__dfxtp_1
X_4258_ clknet_leaf_9_clk _0073_ vssd1 vssd1 vccd1 vccd1 u_core.u_regfile.rf\[31\]\[26\]
+ sky130_fd_sc_hd__dfxtp_1
X_3209_ net505 vssd1 vssd1 vccd1 vccd1 _1606_ sky130_fd_sc_hd__clkbuf_1
X_4189_ _2094_ vssd1 vssd1 vccd1 vccd1 _0553_ sky130_fd_sc_hd__clkbuf_1
XFILLER_0_37_337 vssd1 vssd1 vccd1 vccd1 sky130_fd_sc_hd__fill_1
XFILLER_0_64_167 vssd1 vssd1 vccd1 vccd1 sky130_fd_sc_hd__decap_8
XFILLER_0_64_178 vccd1 vssd1 vccd1 vssd1 sky130_ef_sc_hd__decap_12
XFILLER_0_20_237 vccd1 vssd1 vccd1 vssd1 sky130_ef_sc_hd__decap_12
Xhold190 u_core.u_regfile.rf\[3\]\[6\] vssd1 vssd1 vccd1 vccd1 net223 sky130_fd_sc_hd__dlygate4sd3_1
XFILLER_0_18_27 vssd1 vssd1 vccd1 vccd1 sky130_fd_sc_hd__fill_1
X_3560_ net389 vssd1 vssd1 vccd1 vccd1 _1785_ sky130_fd_sc_hd__clkbuf_1
X_2511_ _0922_ net20 u_core.u_regfile.rf\[6\]\[10\] vssd1 vssd1 vccd1 vccd1 _0969_
+ sky130_fd_sc_hd__o21ai_1
X_3491_ _1731_ _1413_ _1739_ _1480_ _0584_ vssd1 vssd1 vccd1 vccd1 _1750_ sky130_fd_sc_hd__a41o_1
X_2442_ _0898_ _0899_ _0732_ vssd1 vssd1 vccd1 vccd1 _0900_ sky130_fd_sc_hd__a21oi_4
XFILLER_0_59_89 vccd1 vssd1 vccd1 vssd1 sky130_ef_sc_hd__decap_12
X_2373_ _0826_ _0830_ _0772_ _0707_ vssd1 vssd1 vccd1 vccd1 _0831_ sky130_fd_sc_hd__nand4_2
XFILLER_0_75_55 vssd1 vssd1 vccd1 vccd1 sky130_fd_sc_hd__fill_1
X_4112_ net282 vssd1 vssd1 vccd1 vccd1 _2052_ sky130_fd_sc_hd__clkbuf_1
X_4043_ _2017_ vssd1 vssd1 vccd1 vccd1 _0484_ sky130_fd_sc_hd__clkbuf_1
XFILLER_0_19_304 vssd1 vssd1 vccd1 vccd1 sky130_fd_sc_hd__fill_1
XFILLER_0_74_421 vssd1 vssd1 vccd1 vccd1 sky130_fd_sc_hd__decap_6
XFILLER_0_74_410 vssd1 vssd1 vccd1 vccd1 sky130_fd_sc_hd__fill_1
XFILLER_0_59_484 vccd1 vssd1 vccd1 vssd1 sky130_ef_sc_hd__decap_12
X_3827_ _1909_ vssd1 vssd1 vccd1 vccd1 _0376_ sky130_fd_sc_hd__clkbuf_1
XFILLER_0_6_253 vssd1 vssd1 vccd1 vccd1 sky130_fd_sc_hd__decap_8
XFILLER_0_46_189 vssd1 vssd1 vccd1 vccd1 sky130_fd_sc_hd__decap_6
XFILLER_0_6_264 vssd1 vssd1 vccd1 vccd1 sky130_fd_sc_hd__decap_8
X_3758_ _1873_ vssd1 vssd1 vccd1 vccd1 _0343_ sky130_fd_sc_hd__clkbuf_1
X_2709_ _0913_ u_core.u_regfile.rf\[1\]\[16\] _0874_ _0914_ vssd1 vssd1 vccd1 vccd1
+ _1167_ sky130_fd_sc_hd__a31o_1
XFILLER_0_42_373 vccd1 vssd1 vccd1 vssd1 sky130_ef_sc_hd__decap_12
X_3689_ net265 vssd1 vssd1 vccd1 vccd1 _1837_ sky130_fd_sc_hd__clkbuf_1
XFILLER_0_4_80 vssd1 vssd1 vccd1 vccd1 sky130_fd_sc_hd__decap_4
XFILLER_0_37_145 vssd1 vssd1 vccd1 vccd1 sky130_fd_sc_hd__decap_6
XFILLER_0_65_476 vssd1 vssd1 vccd1 vccd1 sky130_fd_sc_hd__decap_4
XFILLER_0_80_457 vccd1 vssd1 vccd1 vssd1 sky130_ef_sc_hd__decap_12
XFILLER_0_29_15 vssd1 vssd1 vccd1 vccd1 sky130_fd_sc_hd__decap_6
XTAP_708 vssd1 vccd1 sky130_fd_sc_hd__tapvpwrvgnd_1
XTAP_719 vssd1 vccd1 sky130_fd_sc_hd__tapvpwrvgnd_1
XFILLER_0_75_207 vssd1 vssd1 vccd1 vccd1 sky130_fd_sc_hd__fill_1
XFILLER_0_0_27 vssd1 vssd1 vccd1 vccd1 sky130_fd_sc_hd__fill_1
X_2991_ _0979_ _0984_ vssd1 vssd1 vccd1 vccd1 _1449_ sky130_fd_sc_hd__nand2_1
XFILLER_0_61_57 vssd1 vssd1 vccd1 vccd1 sky130_fd_sc_hd__fill_2
XFILLER_0_61_68 vssd1 vssd1 vccd1 vccd1 sky130_fd_sc_hd__fill_1
X_4730_ clknet_leaf_16_clk _0531_ net23 vssd1 vssd1 vccd1 vccd1 net7 sky130_fd_sc_hd__dfrtp_2
X_4661_ clknet_leaf_35_clk _0462_ vssd1 vssd1 vccd1 vccd1 u_core.u_regfile.rf\[26\]\[31\]
+ sky130_fd_sc_hd__dfxtp_1
X_3612_ _1798_ vssd1 vssd1 vccd1 vccd1 _0272_ sky130_fd_sc_hd__clkbuf_1
X_4592_ clknet_leaf_23_clk _0393_ vssd1 vssd1 vccd1 vccd1 u_core.u_regfile.rf\[27\]\[26\]
+ sky130_fd_sc_hd__dfxtp_1
X_3543_ _1776_ vssd1 vssd1 vccd1 vccd1 _0225_ sky130_fd_sc_hd__clkbuf_1
X_3474_ _1731_ _1725_ _1739_ _1726_ _0604_ vssd1 vssd1 vccd1 vccd1 _1740_ sky130_fd_sc_hd__a41o_1
X_2425_ _0769_ _0880_ _0702_ _0881_ _0882_ vssd1 vssd1 vccd1 vccd1 _0883_ sky130_fd_sc_hd__a221o_2
X_2356_ u_core.u_regfile.rf\[4\]\[26\] _0751_ _0810_ _0813_ vssd1 vssd1 vccd1 vccd1
+ _0814_ sky130_fd_sc_hd__o211a_1
X_2287_ _0744_ vssd1 vssd1 vccd1 vccd1 _0745_ sky130_fd_sc_hd__buf_4
X_4026_ net258 vssd1 vssd1 vccd1 vccd1 _2009_ sky130_fd_sc_hd__clkbuf_1
XFILLER_0_66_218 vssd1 vssd1 vccd1 vccd1 sky130_fd_sc_hd__fill_2
XFILLER_0_19_167 vssd1 vssd1 vccd1 vccd1 sky130_fd_sc_hd__fill_1
XFILLER_0_34_115 vssd1 vssd1 vccd1 vccd1 sky130_fd_sc_hd__decap_3
XFILLER_0_62_424 vssd1 vssd1 vccd1 vccd1 sky130_fd_sc_hd__decap_4
XFILLER_0_34_148 vssd1 vssd1 vccd1 vccd1 sky130_fd_sc_hd__decap_4
XFILLER_0_85_505 vssd1 vssd1 vccd1 vccd1 sky130_fd_sc_hd__decap_4
XFILLER_0_57_218 vssd1 vssd1 vccd1 vccd1 sky130_fd_sc_hd__decap_6
XFILLER_0_38_421 vssd1 vssd1 vccd1 vccd1 sky130_fd_sc_hd__fill_1
XFILLER_0_0_237 vccd1 vssd1 vccd1 vssd1 sky130_ef_sc_hd__decap_12
XTAP_505 vssd1 vccd1 sky130_fd_sc_hd__tapvpwrvgnd_1
XTAP_516 vssd1 vccd1 sky130_fd_sc_hd__tapvpwrvgnd_1
X_2210_ u_timer.count_reg\[20\] _0666_ u_timer.count_reg\[16\] _0667_ _0668_ vssd1
+ vssd1 vccd1 vccd1 _0669_ sky130_fd_sc_hd__o221a_1
XTAP_527 vssd1 vccd1 sky130_fd_sc_hd__tapvpwrvgnd_1
XTAP_538 vssd1 vccd1 sky130_fd_sc_hd__tapvpwrvgnd_1
XTAP_549 vssd1 vccd1 sky130_fd_sc_hd__tapvpwrvgnd_1
X_3190_ _1596_ vssd1 vssd1 vccd1 vccd1 _0052_ sky130_fd_sc_hd__clkbuf_1
X_2141_ net547 vssd1 vssd1 vccd1 vccd1 _0600_ sky130_fd_sc_hd__inv_2
XFILLER_0_8_304 vssd1 vssd1 vccd1 vccd1 sky130_fd_sc_hd__decap_4
X_2974_ _1423_ _1424_ _1428_ _1431_ vssd1 vssd1 vccd1 vccd1 _1432_ sky130_fd_sc_hd__and4_1
XFILLER_0_56_251 vssd1 vssd1 vccd1 vccd1 sky130_fd_sc_hd__fill_1
X_4713_ clknet_leaf_25_clk _0514_ vssd1 vssd1 vccd1 vccd1 u_core.u_regfile.rf\[25\]\[19\]
+ sky130_fd_sc_hd__dfxtp_1
XFILLER_0_16_137 vssd1 vssd1 vccd1 vccd1 sky130_fd_sc_hd__decap_3
X_4644_ clknet_leaf_37_clk _0445_ vssd1 vssd1 vccd1 vccd1 u_core.u_regfile.rf\[26\]\[14\]
+ sky130_fd_sc_hd__dfxtp_1
X_4575_ clknet_leaf_38_clk _0376_ vssd1 vssd1 vccd1 vccd1 u_core.u_regfile.rf\[27\]\[9\]
+ sky130_fd_sc_hd__dfxtp_1
XFILLER_0_12_354 vssd1 vssd1 vccd1 vccd1 sky130_fd_sc_hd__decap_6
X_3526_ net381 vssd1 vssd1 vccd1 vccd1 _1768_ sky130_fd_sc_hd__clkbuf_1
X_3457_ _1724_ _1704_ _1727_ vssd1 vssd1 vccd1 vccd1 _0188_ sky130_fd_sc_hd__o21ai_1
X_2408_ _0685_ _0688_ vssd1 vssd1 vccd1 vccd1 _0866_ sky130_fd_sc_hd__nand2_4
X_3388_ _0712_ vssd1 vssd1 vccd1 vccd1 _1674_ sky130_fd_sc_hd__clkbuf_4
X_2339_ u_core.u_regfile.rf\[4\]\[27\] _0756_ _0796_ vssd1 vssd1 vccd1 vccd1 _0797_
+ sky130_fd_sc_hd__a21oi_1
X_4009_ _2000_ vssd1 vssd1 vccd1 vccd1 _0467_ sky130_fd_sc_hd__clkbuf_1
XFILLER_0_67_505 vssd1 vssd1 vccd1 vccd1 sky130_fd_sc_hd__decap_4
XFILLER_0_1_81 vccd1 vssd1 vccd1 vssd1 sky130_ef_sc_hd__decap_12
XFILLER_0_35_435 vssd1 vssd1 vccd1 vccd1 sky130_fd_sc_hd__fill_1
Xhold50 u_core.u_regfile.rf\[5\]\[13\] vssd1 vssd1 vccd1 vccd1 net83 sky130_fd_sc_hd__dlygate4sd3_1
Xhold83 u_core.u_regfile.rf\[6\]\[28\] vssd1 vssd1 vccd1 vccd1 net116 sky130_fd_sc_hd__dlygate4sd3_1
Xhold61 u_core.u_regfile.rf\[28\]\[21\] vssd1 vssd1 vccd1 vccd1 net94 sky130_fd_sc_hd__dlygate4sd3_1
Xhold72 u_core.u_regfile.rf\[28\]\[31\] vssd1 vssd1 vccd1 vccd1 net105 sky130_fd_sc_hd__dlygate4sd3_1
Xhold94 u_core.u_regfile.rf\[6\]\[17\] vssd1 vssd1 vccd1 vccd1 net127 sky130_fd_sc_hd__dlygate4sd3_1
XFILLER_0_42_15 vccd1 vssd1 vccd1 vssd1 sky130_ef_sc_hd__decap_12
X_2690_ _0879_ u_core.u_regfile.rf\[5\]\[10\] _0724_ _0734_ _0977_ vssd1 vssd1 vccd1
+ vccd1 _1148_ sky130_fd_sc_hd__o2111ai_1
XFILLER_0_41_449 vssd1 vssd1 vccd1 vccd1 sky130_fd_sc_hd__fill_1
XFILLER_0_6_15 vccd1 vssd1 vccd1 vssd1 sky130_ef_sc_hd__decap_12
X_4360_ clknet_leaf_18_clk _0171_ vssd1 vssd1 vccd1 vccd1 u_core.u_regfile.rf\[5\]\[28\]
+ sky130_fd_sc_hd__dfxtp_1
X_3311_ _1646_ vssd1 vssd1 vccd1 vccd1 _0123_ sky130_fd_sc_hd__clkbuf_1
XTAP_324 vssd1 vccd1 sky130_fd_sc_hd__tapvpwrvgnd_1
XTAP_313 vssd1 vccd1 sky130_fd_sc_hd__tapvpwrvgnd_1
XTAP_302 vssd1 vccd1 sky130_fd_sc_hd__tapvpwrvgnd_1
X_4291_ clknet_leaf_1_clk _0102_ vssd1 vssd1 vccd1 vccd1 u_core.u_regfile.rf\[6\]\[23\]
+ sky130_fd_sc_hd__dfxtp_1
XTAP_346 vssd1 vccd1 sky130_fd_sc_hd__tapvpwrvgnd_1
XTAP_335 vssd1 vccd1 sky130_fd_sc_hd__tapvpwrvgnd_1
XTAP_357 vssd1 vccd1 sky130_fd_sc_hd__tapvpwrvgnd_1
X_3242_ _1622_ vssd1 vssd1 vccd1 vccd1 _0078_ sky130_fd_sc_hd__clkbuf_1
XTAP_368 vssd1 vccd1 sky130_fd_sc_hd__tapvpwrvgnd_1
XTAP_379 vssd1 vccd1 sky130_fd_sc_hd__tapvpwrvgnd_1
X_3173_ net415 _1585_ net520 vssd1 vssd1 vccd1 vccd1 _1588_ sky130_fd_sc_hd__a21oi_1
X_2124_ u_timer.count_reg\[28\] _0582_ vssd1 vssd1 vccd1 vccd1 _0583_ sky130_fd_sc_hd__nor2_1
XFILLER_0_83_55 vssd1 vssd1 vccd1 vccd1 sky130_fd_sc_hd__fill_1
Xclkbuf_leaf_46_clk clknet_2_0__leaf_clk vssd1 vssd1 vccd1 vccd1 clknet_leaf_46_clk
+ sky130_fd_sc_hd__clkbuf_16
XPHY_19 vssd1 vssd1 vccd1 vccd1 sky130_fd_sc_hd__decap_3
X_2957_ _1414_ _1366_ _0966_ vssd1 vssd1 vccd1 vccd1 _1415_ sky130_fd_sc_hd__o21ai_4
XFILLER_0_17_457 vssd1 vssd1 vccd1 vccd1 sky130_fd_sc_hd__decap_4
X_2888_ _0776_ _1304_ _0741_ _1245_ vssd1 vssd1 vccd1 vccd1 _1346_ sky130_fd_sc_hd__or4_1
XFILLER_0_44_298 vssd1 vssd1 vccd1 vccd1 sky130_fd_sc_hd__fill_1
X_4627_ clknet_leaf_8_clk _0428_ vssd1 vssd1 vccd1 vccd1 u_core.u_regfile.rf\[1\]\[29\]
+ sky130_fd_sc_hd__dfxtp_1
XFILLER_0_4_362 vssd1 vssd1 vccd1 vccd1 sky130_fd_sc_hd__fill_2
Xhold520 u_timer.threshold_reg\[9\] vssd1 vssd1 vccd1 vccd1 net553 sky130_fd_sc_hd__dlygate4sd3_1
X_4558_ clknet_leaf_19_clk _0359_ vssd1 vssd1 vccd1 vccd1 u_core.u_regfile.rf\[28\]\[24\]
+ sky130_fd_sc_hd__dfxtp_1
X_3509_ _1759_ vssd1 vssd1 vccd1 vccd1 _0208_ sky130_fd_sc_hd__clkbuf_1
X_4489_ clknet_leaf_26_clk _0290_ vssd1 vssd1 vccd1 vccd1 u_core.u_regfile.rf\[30\]\[19\]
+ sky130_fd_sc_hd__dfxtp_1
XTAP_880 vssd1 vccd1 sky130_fd_sc_hd__tapvpwrvgnd_1
XTAP_891 vssd1 vccd1 sky130_fd_sc_hd__tapvpwrvgnd_1
Xclkbuf_leaf_37_clk clknet_2_1__leaf_clk vssd1 vssd1 vccd1 vccd1 clknet_leaf_37_clk
+ sky130_fd_sc_hd__clkbuf_16
XFILLER_0_67_324 vssd1 vssd1 vccd1 vccd1 sky130_fd_sc_hd__fill_2
XFILLER_0_67_357 vssd1 vssd1 vccd1 vccd1 sky130_fd_sc_hd__decap_6
XFILLER_0_12_29 vssd1 vssd1 vccd1 vccd1 sky130_fd_sc_hd__decap_8
XFILLER_0_23_427 vssd1 vssd1 vccd1 vccd1 sky130_fd_sc_hd__fill_1
Xoutput5 net5 vssd1 vssd1 vccd1 vccd1 gpio_pins[2] sky130_fd_sc_hd__clkbuf_4
Xclkbuf_leaf_28_clk clknet_2_3__leaf_clk vssd1 vssd1 vccd1 vccd1 clknet_leaf_28_clk
+ sky130_fd_sc_hd__clkbuf_16
XFILLER_0_46_508 vssd1 vssd1 vccd1 vccd1 sky130_fd_sc_hd__fill_2
XFILLER_0_85_165 vssd1 vssd1 vccd1 vccd1 sky130_fd_sc_hd__decap_3
X_3860_ net167 vssd1 vssd1 vccd1 vccd1 _1926_ sky130_fd_sc_hd__clkbuf_1
X_2811_ u_core.u_regfile.rf\[31\]\[22\] _0895_ _0874_ _0738_ vssd1 vssd1 vccd1 vccd1
+ _1269_ sky130_fd_sc_hd__a2bb2o_1
X_3791_ _1868_ _1345_ _1349_ _1891_ vssd1 vssd1 vccd1 vccd1 _0358_ sky130_fd_sc_hd__o31ai_1
X_2742_ _0685_ u_core.u_regfile.rf\[29\]\[17\] _1199_ vssd1 vssd1 vccd1 vccd1 _1200_
+ sky130_fd_sc_hd__a21oi_2
XFILLER_0_81_393 vccd1 vssd1 vccd1 vssd1 sky130_ef_sc_hd__decap_12
X_4412_ clknet_leaf_32_clk _0223_ vssd1 vssd1 vccd1 vccd1 u_core.u_regfile.rf\[29\]\[16\]
+ sky130_fd_sc_hd__dfxtp_1
X_2673_ _1073_ _1102_ _1130_ vssd1 vssd1 vccd1 vccd1 _1131_ sky130_fd_sc_hd__nand3_1
XFILLER_0_41_279 vssd1 vssd1 vccd1 vccd1 sky130_fd_sc_hd__fill_1
XFILLER_0_78_77 vssd1 vssd1 vccd1 vccd1 sky130_fd_sc_hd__decap_6
X_4343_ clknet_leaf_31_clk _0154_ vssd1 vssd1 vccd1 vccd1 u_core.u_regfile.rf\[5\]\[11\]
+ sky130_fd_sc_hd__dfxtp_1
X_4274_ clknet_leaf_49_clk _0085_ vssd1 vssd1 vccd1 vccd1 u_core.u_regfile.rf\[6\]\[6\]
+ sky130_fd_sc_hd__dfxtp_1
X_3225_ net551 vssd1 vssd1 vccd1 vccd1 _1614_ sky130_fd_sc_hd__clkbuf_1
XTAP_176 vssd1 vccd1 sky130_fd_sc_hd__tapvpwrvgnd_1
XTAP_187 vssd1 vccd1 sky130_fd_sc_hd__tapvpwrvgnd_1
XTAP_198 vssd1 vccd1 sky130_fd_sc_hd__tapvpwrvgnd_1
X_3156_ net517 vssd1 vssd1 vccd1 vccd1 _1577_ sky130_fd_sc_hd__inv_2
X_3087_ u_timer.count_reg\[13\] u_timer.count_reg\[12\] _1515_ u_timer.count_reg\[14\]
+ vssd1 vssd1 vccd1 vccd1 _1526_ sky130_fd_sc_hd__a31o_1
Xclkbuf_leaf_19_clk clknet_2_3__leaf_clk vssd1 vssd1 vccd1 vccd1 clknet_leaf_19_clk
+ sky130_fd_sc_hd__clkbuf_16
XFILLER_0_11_3 vccd1 vssd1 vccd1 vssd1 sky130_ef_sc_hd__decap_12
XFILLER_0_37_508 vssd1 vssd1 vccd1 vccd1 sky130_fd_sc_hd__fill_2
XFILLER_0_9_498 vssd1 vssd1 vccd1 vccd1 sky130_fd_sc_hd__decap_6
X_3989_ _1990_ vssd1 vssd1 vccd1 vccd1 _0457_ sky130_fd_sc_hd__clkbuf_1
Xhold350 u_core.u_regfile.rf\[29\]\[17\] vssd1 vssd1 vccd1 vccd1 net383 sky130_fd_sc_hd__dlygate4sd3_1
Xhold361 u_core.u_regfile.rf\[1\]\[0\] vssd1 vssd1 vccd1 vccd1 net394 sky130_fd_sc_hd__dlygate4sd3_1
Xhold372 u_core.u_regfile.rf\[1\]\[2\] vssd1 vssd1 vccd1 vccd1 net405 sky130_fd_sc_hd__dlygate4sd3_1
Xhold394 u_core.u_regfile.rf\[4\]\[22\] vssd1 vssd1 vccd1 vccd1 net427 sky130_fd_sc_hd__dlygate4sd3_1
Xhold383 u_core.u_regfile.rf\[29\]\[16\] vssd1 vssd1 vccd1 vccd1 net416 sky130_fd_sc_hd__dlygate4sd3_1
XFILLER_0_23_28 vssd1 vssd1 vccd1 vccd1 sky130_fd_sc_hd__decap_8
XFILLER_0_55_316 vssd1 vssd1 vccd1 vccd1 sky130_fd_sc_hd__decap_8
XFILLER_0_67_154 vssd1 vssd1 vccd1 vccd1 sky130_fd_sc_hd__fill_1
XFILLER_0_55_327 vssd1 vssd1 vccd1 vccd1 sky130_fd_sc_hd__decap_8
X_3010_ _0859_ _0869_ vssd1 vssd1 vccd1 vccd1 _1468_ sky130_fd_sc_hd__or2_2
XFILLER_0_64_79 vssd1 vssd1 vccd1 vccd1 sky130_fd_sc_hd__decap_4
X_3912_ net403 vssd1 vssd1 vccd1 vccd1 _1952_ sky130_fd_sc_hd__clkbuf_1
X_3843_ _1917_ vssd1 vssd1 vccd1 vccd1 _0384_ sky130_fd_sc_hd__clkbuf_1
X_3774_ _1472_ net555 _1868_ vssd1 vssd1 vccd1 vccd1 _1883_ sky130_fd_sc_hd__mux2_1
XFILLER_0_14_246 vssd1 vssd1 vccd1 vccd1 sky130_fd_sc_hd__decap_6
X_2725_ _1180_ _1181_ _0885_ _1182_ _0743_ vssd1 vssd1 vccd1 vccd1 _1183_ sky130_fd_sc_hd__a311oi_4
X_2656_ _0776_ _0698_ _1112_ _1106_ vssd1 vssd1 vccd1 vccd1 _1114_ sky130_fd_sc_hd__o31a_1
Xclkbuf_leaf_8_clk clknet_2_2__leaf_clk vssd1 vssd1 vccd1 vccd1 clknet_leaf_8_clk
+ sky130_fd_sc_hd__clkbuf_16
XFILLER_0_1_184 vccd1 vssd1 vccd1 vssd1 sky130_ef_sc_hd__decap_12
X_2587_ _0939_ _0709_ _0722_ vssd1 vssd1 vccd1 vccd1 _1045_ sky130_fd_sc_hd__a21oi_1
XFILLER_0_59_3 vccd1 vssd1 vccd1 vssd1 sky130_ef_sc_hd__decap_12
X_4326_ clknet_leaf_2_clk _0137_ vssd1 vssd1 vccd1 vccd1 u_core.u_regfile.rf\[4\]\[26\]
+ sky130_fd_sc_hd__dfxtp_1
X_4257_ clknet_leaf_32_clk _0072_ vssd1 vssd1 vccd1 vccd1 u_core.u_regfile.rf\[31\]\[25\]
+ sky130_fd_sc_hd__dfxtp_1
X_4188_ net273 vssd1 vssd1 vccd1 vccd1 _2094_ sky130_fd_sc_hd__clkbuf_1
X_3208_ _1605_ vssd1 vssd1 vccd1 vccd1 _0061_ sky130_fd_sc_hd__clkbuf_1
X_3139_ _1561_ vssd1 vssd1 vccd1 vccd1 _0030_ sky130_fd_sc_hd__clkbuf_1
XFILLER_0_54_90 vssd1 vssd1 vccd1 vccd1 sky130_fd_sc_hd__decap_3
XFILLER_0_77_452 vssd1 vssd1 vccd1 vccd1 sky130_fd_sc_hd__decap_4
XFILLER_0_9_284 vccd1 vssd1 vccd1 vssd1 sky130_ef_sc_hd__decap_12
XFILLER_0_9_273 vssd1 vssd1 vccd1 vccd1 sky130_fd_sc_hd__decap_6
XFILLER_0_64_157 vssd1 vssd1 vccd1 vccd1 sky130_fd_sc_hd__decap_4
XFILLER_0_60_352 vccd1 vssd1 vccd1 vssd1 sky130_ef_sc_hd__decap_12
XFILLER_0_60_385 vssd1 vssd1 vccd1 vccd1 sky130_fd_sc_hd__fill_1
Xhold180 u_core.u_regfile.rf\[25\]\[28\] vssd1 vssd1 vccd1 vccd1 net213 sky130_fd_sc_hd__dlygate4sd3_1
Xhold191 u_core.u_regfile.rf\[24\]\[6\] vssd1 vssd1 vccd1 vccd1 net224 sky130_fd_sc_hd__dlygate4sd3_1
XFILLER_0_50_15 vccd1 vssd1 vccd1 vssd1 sky130_ef_sc_hd__decap_12
XFILLER_0_55_113 vssd1 vssd1 vccd1 vccd1 sky130_fd_sc_hd__fill_1
XFILLER_0_36_360 vssd1 vssd1 vccd1 vccd1 sky130_fd_sc_hd__decap_4
XFILLER_0_70_105 vssd1 vssd1 vccd1 vccd1 sky130_fd_sc_hd__decap_3
XFILLER_0_3_405 vccd1 vssd1 vccd1 vssd1 sky130_ef_sc_hd__decap_12
XFILLER_0_51_330 vssd1 vssd1 vccd1 vccd1 sky130_fd_sc_hd__decap_3
X_2510_ _0860_ u_core.u_regfile.rf\[7\]\[10\] _0861_ vssd1 vssd1 vccd1 vccd1 _0968_
+ sky130_fd_sc_hd__nand3_1
XFILLER_0_3_449 vccd1 vssd1 vccd1 vssd1 sky130_ef_sc_hd__decap_12
XFILLER_0_51_352 vssd1 vssd1 vccd1 vccd1 sky130_fd_sc_hd__decap_6
X_3490_ _0826_ _1686_ _1705_ _1146_ vssd1 vssd1 vccd1 vccd1 _1749_ sky130_fd_sc_hd__nand4_1
X_2441_ _0778_ _0725_ vssd1 vssd1 vccd1 vccd1 _0899_ sky130_fd_sc_hd__nand2_1
XFILLER_0_51_396 vssd1 vssd1 vccd1 vccd1 sky130_fd_sc_hd__fill_2
XFILLER_0_59_35 vssd1 vssd1 vccd1 vccd1 sky130_fd_sc_hd__fill_1
X_2372_ _0771_ _0774_ _0694_ u_core.u_regfile.rf\[5\]\[25\] _0829_ vssd1 vssd1 vccd1
+ vccd1 _0830_ sky130_fd_sc_hd__o221a_1
X_4111_ _2051_ vssd1 vssd1 vccd1 vccd1 _0518_ sky130_fd_sc_hd__clkbuf_1
X_4042_ net186 vssd1 vssd1 vccd1 vccd1 _2017_ sky130_fd_sc_hd__clkbuf_1
XFILLER_0_78_216 vssd1 vssd1 vccd1 vccd1 sky130_fd_sc_hd__fill_2
XFILLER_0_24_82 vssd1 vssd1 vccd1 vccd1 sky130_fd_sc_hd__fill_2
XFILLER_0_59_496 vssd1 vssd1 vccd1 vccd1 sky130_fd_sc_hd__decap_8
XFILLER_0_74_477 vccd1 vssd1 vccd1 vssd1 sky130_ef_sc_hd__decap_12
X_3826_ net176 vssd1 vssd1 vccd1 vccd1 _1909_ sky130_fd_sc_hd__clkbuf_1
XFILLER_0_6_287 vssd1 vssd1 vccd1 vccd1 sky130_fd_sc_hd__decap_4
X_3757_ _1419_ net504 _1868_ vssd1 vssd1 vccd1 vccd1 _1873_ sky130_fd_sc_hd__mux2_1
X_2708_ _1163_ _1165_ vssd1 vssd1 vccd1 vccd1 _1166_ sky130_fd_sc_hd__nand2_1
XFILLER_0_42_385 vssd1 vssd1 vccd1 vccd1 sky130_fd_sc_hd__decap_8
XFILLER_0_42_396 vssd1 vssd1 vccd1 vccd1 sky130_fd_sc_hd__fill_1
X_3688_ _1836_ vssd1 vssd1 vccd1 vccd1 _0310_ sky130_fd_sc_hd__clkbuf_1
X_2639_ _0731_ _0954_ u_core.u_regfile.rf\[28\]\[4\] vssd1 vssd1 vccd1 vccd1 _1097_
+ sky130_fd_sc_hd__o21ai_1
X_4309_ clknet_leaf_47_clk _0120_ vssd1 vssd1 vccd1 vccd1 u_core.u_regfile.rf\[4\]\[9\]
+ sky130_fd_sc_hd__dfxtp_1
XFILLER_0_80_469 vssd1 vssd1 vccd1 vccd1 sky130_fd_sc_hd__decap_6
XFILLER_0_20_29 vccd1 vssd1 vccd1 vssd1 sky130_ef_sc_hd__decap_12
XFILLER_0_33_330 vssd1 vssd1 vccd1 vccd1 sky130_fd_sc_hd__decap_6
XFILLER_0_21_503 vssd1 vssd1 vccd1 vccd1 sky130_fd_sc_hd__fill_1
XTAP_709 vssd1 vccd1 sky130_fd_sc_hd__tapvpwrvgnd_1
XFILLER_0_45_15 vccd1 vssd1 vccd1 vssd1 sky130_ef_sc_hd__decap_12
XFILLER_0_8_508 vssd1 vssd1 vccd1 vccd1 sky130_fd_sc_hd__fill_2
X_2990_ _1446_ _1447_ vssd1 vssd1 vccd1 vccd1 _1448_ sky130_fd_sc_hd__nand2_1
XFILLER_0_28_135 vssd1 vssd1 vccd1 vccd1 sky130_fd_sc_hd__decap_4
XFILLER_0_9_15 vccd1 vssd1 vccd1 vssd1 sky130_ef_sc_hd__decap_12
X_4660_ clknet_leaf_33_clk _0461_ vssd1 vssd1 vccd1 vccd1 u_core.u_regfile.rf\[26\]\[30\]
+ sky130_fd_sc_hd__dfxtp_1
XFILLER_0_56_499 vssd1 vssd1 vccd1 vccd1 sky130_fd_sc_hd__fill_1
XFILLER_0_71_447 vssd1 vssd1 vccd1 vccd1 sky130_fd_sc_hd__fill_1
XFILLER_0_71_436 vssd1 vssd1 vccd1 vccd1 sky130_fd_sc_hd__decap_4
XFILLER_0_3_202 vssd1 vssd1 vccd1 vccd1 sky130_fd_sc_hd__decap_8
X_3611_ net329 vssd1 vssd1 vccd1 vccd1 _1798_ sky130_fd_sc_hd__clkbuf_1
XFILLER_0_24_330 vccd1 vssd1 vccd1 vssd1 sky130_ef_sc_hd__decap_12
XFILLER_0_36_190 vssd1 vssd1 vccd1 vccd1 sky130_fd_sc_hd__decap_6
X_4591_ clknet_leaf_47_clk _0392_ vssd1 vssd1 vccd1 vccd1 u_core.u_regfile.rf\[27\]\[25\]
+ sky130_fd_sc_hd__dfxtp_1
XFILLER_0_3_257 vccd1 vssd1 vccd1 vssd1 sky130_ef_sc_hd__decap_12
X_3542_ net395 vssd1 vssd1 vccd1 vccd1 _1776_ sky130_fd_sc_hd__clkbuf_1
XFILLER_0_51_193 vssd1 vssd1 vccd1 vccd1 sky130_fd_sc_hd__fill_1
X_3473_ _1713_ vssd1 vssd1 vccd1 vccd1 _1739_ sky130_fd_sc_hd__clkbuf_4
X_2424_ _0757_ _0740_ u_core.u_regfile.rf\[28\]\[12\] vssd1 vssd1 vccd1 vccd1 _0882_
+ sky130_fd_sc_hd__o21a_1
X_2355_ _0812_ vssd1 vssd1 vccd1 vccd1 _0813_ sky130_fd_sc_hd__clkbuf_8
X_2286_ _0721_ _0720_ _0686_ vssd1 vssd1 vccd1 vccd1 _0744_ sky130_fd_sc_hd__o21a_4
XFILLER_0_79_503 vssd1 vssd1 vccd1 vccd1 sky130_fd_sc_hd__fill_1
X_4025_ _2008_ vssd1 vssd1 vccd1 vccd1 _0475_ sky130_fd_sc_hd__clkbuf_1
XFILLER_0_19_135 vssd1 vssd1 vccd1 vccd1 sky130_fd_sc_hd__fill_1
XFILLER_0_74_296 vssd1 vssd1 vccd1 vccd1 sky130_fd_sc_hd__fill_1
XFILLER_0_34_127 vssd1 vssd1 vccd1 vccd1 sky130_fd_sc_hd__decap_4
X_3809_ _1900_ vssd1 vssd1 vccd1 vccd1 _0367_ sky130_fd_sc_hd__clkbuf_1
XFILLER_0_15_341 vssd1 vssd1 vccd1 vccd1 sky130_fd_sc_hd__fill_1
X_4789_ clknet_leaf_22_clk _0557_ vssd1 vssd1 vccd1 vccd1 u_core.u_regfile.rf\[3\]\[22\]
+ sky130_fd_sc_hd__dfxtp_1
XFILLER_0_30_355 vssd1 vssd1 vccd1 vccd1 sky130_fd_sc_hd__decap_3
XFILLER_0_65_285 vssd1 vssd1 vccd1 vccd1 sky130_fd_sc_hd__fill_1
XFILLER_0_65_296 vssd1 vssd1 vccd1 vccd1 sky130_fd_sc_hd__fill_1
XFILLER_0_21_300 vssd1 vssd1 vccd1 vccd1 sky130_fd_sc_hd__fill_1
XFILLER_0_21_311 vssd1 vssd1 vccd1 vccd1 sky130_fd_sc_hd__fill_1
XFILLER_0_0_249 vssd1 vssd1 vccd1 vccd1 sky130_fd_sc_hd__decap_3
XTAP_506 vssd1 vccd1 sky130_fd_sc_hd__tapvpwrvgnd_1
XTAP_517 vssd1 vccd1 sky130_fd_sc_hd__tapvpwrvgnd_1
XTAP_528 vssd1 vccd1 sky130_fd_sc_hd__tapvpwrvgnd_1
XTAP_539 vssd1 vccd1 sky130_fd_sc_hd__tapvpwrvgnd_1
X_2140_ _0583_ _0596_ _0598_ vssd1 vssd1 vccd1 vccd1 _0599_ sky130_fd_sc_hd__o21a_1
X_2973_ _1430_ _0772_ _0701_ vssd1 vssd1 vccd1 vccd1 _1431_ sky130_fd_sc_hd__and3_1
XFILLER_0_8_349 vssd1 vssd1 vccd1 vccd1 sky130_fd_sc_hd__decap_8
XFILLER_0_29_477 vssd1 vssd1 vccd1 vccd1 sky130_fd_sc_hd__fill_2
X_4712_ clknet_leaf_24_clk _0513_ vssd1 vssd1 vccd1 vccd1 u_core.u_regfile.rf\[25\]\[18\]
+ sky130_fd_sc_hd__dfxtp_1
XFILLER_0_16_149 vccd1 vssd1 vccd1 vssd1 sky130_ef_sc_hd__decap_12
XFILLER_0_56_285 vssd1 vssd1 vccd1 vccd1 sky130_fd_sc_hd__fill_1
X_4643_ clknet_leaf_47_clk _0444_ vssd1 vssd1 vccd1 vccd1 u_core.u_regfile.rf\[26\]\[13\]
+ sky130_fd_sc_hd__dfxtp_1
X_4574_ clknet_leaf_24_clk _0375_ vssd1 vssd1 vccd1 vccd1 u_core.u_regfile.rf\[27\]\[8\]
+ sky130_fd_sc_hd__dfxtp_1
X_3525_ _1767_ vssd1 vssd1 vccd1 vccd1 _0216_ sky130_fd_sc_hd__clkbuf_1
X_3456_ _1705_ _1725_ _1714_ _1726_ _0617_ vssd1 vssd1 vccd1 vccd1 _1727_ sky130_fd_sc_hd__a41o_1
X_2407_ _0700_ _0802_ u_core.u_regfile.rf\[4\]\[14\] vssd1 vssd1 vccd1 vccd1 _0865_
+ sky130_fd_sc_hd__a21o_1
XFILLER_0_41_3 vccd1 vssd1 vccd1 vssd1 sky130_ef_sc_hd__decap_12
X_3387_ _1405_ _1672_ _1673_ net122 vssd1 vssd1 vccd1 vccd1 _0172_ sky130_fd_sc_hd__o31a_1
X_2338_ _0738_ u_core.u_regfile.rf\[7\]\[27\] _0762_ _0751_ _0795_ vssd1 vssd1 vccd1
+ vccd1 _0796_ sky130_fd_sc_hd__o311a_1
X_2269_ _0726_ vssd1 vssd1 vccd1 vccd1 _0727_ sky130_fd_sc_hd__clkbuf_8
X_4008_ net199 vssd1 vssd1 vccd1 vccd1 _2000_ sky130_fd_sc_hd__clkbuf_1
XFILLER_0_82_509 vssd1 vssd1 vccd1 vccd1 sky130_fd_sc_hd__fill_1
XFILLER_0_1_93 vccd1 vssd1 vccd1 vssd1 sky130_ef_sc_hd__decap_12
XFILLER_0_47_230 vssd1 vssd1 vccd1 vccd1 sky130_fd_sc_hd__decap_6
XFILLER_0_35_447 vssd1 vssd1 vccd1 vccd1 sky130_fd_sc_hd__fill_1
XFILLER_0_47_285 vccd1 vssd1 vccd1 vssd1 sky130_ef_sc_hd__decap_12
XFILLER_0_50_439 vssd1 vssd1 vccd1 vccd1 sky130_fd_sc_hd__fill_1
XFILLER_0_62_299 vssd1 vssd1 vccd1 vccd1 sky130_fd_sc_hd__decap_6
XFILLER_0_30_141 vssd1 vssd1 vccd1 vccd1 sky130_fd_sc_hd__decap_8
Xhold40 u_core.u_regfile.rf\[6\]\[10\] vssd1 vssd1 vccd1 vccd1 net73 sky130_fd_sc_hd__dlygate4sd3_1
Xhold73 u_core.u_regfile.rf\[7\]\[14\] vssd1 vssd1 vccd1 vccd1 net106 sky130_fd_sc_hd__dlygate4sd3_1
Xhold51 u_core.u_regfile.rf\[7\]\[8\] vssd1 vssd1 vccd1 vccd1 net84 sky130_fd_sc_hd__dlygate4sd3_1
Xhold62 u_core.u_regfile.rf\[7\]\[31\] vssd1 vssd1 vccd1 vccd1 net95 sky130_fd_sc_hd__dlygate4sd3_1
Xhold95 u_core.u_regfile.rf\[6\]\[16\] vssd1 vssd1 vccd1 vccd1 net128 sky130_fd_sc_hd__dlygate4sd3_1
Xhold84 u_core.u_regfile.rf\[28\]\[27\] vssd1 vssd1 vccd1 vccd1 net117 sky130_fd_sc_hd__dlygate4sd3_1
XFILLER_0_73_509 vssd1 vssd1 vccd1 vccd1 sky130_fd_sc_hd__fill_1
XFILLER_0_42_27 vssd1 vssd1 vccd1 vccd1 sky130_fd_sc_hd__fill_1
XFILLER_0_42_38 vssd1 vssd1 vccd1 vccd1 sky130_fd_sc_hd__fill_2
XFILLER_0_5_308 vssd1 vssd1 vccd1 vccd1 sky130_fd_sc_hd__fill_1
XFILLER_0_1_503 vssd1 vssd1 vccd1 vccd1 sky130_fd_sc_hd__fill_1
X_3310_ net538 vssd1 vssd1 vccd1 vccd1 _1646_ sky130_fd_sc_hd__clkbuf_1
XFILLER_0_6_27 vssd1 vssd1 vccd1 vccd1 sky130_fd_sc_hd__fill_1
XTAP_314 vssd1 vccd1 sky130_fd_sc_hd__tapvpwrvgnd_1
XTAP_303 vssd1 vccd1 sky130_fd_sc_hd__tapvpwrvgnd_1
X_4290_ clknet_leaf_1_clk _0101_ vssd1 vssd1 vccd1 vccd1 u_core.u_regfile.rf\[6\]\[22\]
+ sky130_fd_sc_hd__dfxtp_1
XFILLER_0_67_35 vssd1 vssd1 vccd1 vccd1 sky130_fd_sc_hd__fill_1
XTAP_347 vssd1 vccd1 sky130_fd_sc_hd__tapvpwrvgnd_1
XTAP_336 vssd1 vccd1 sky130_fd_sc_hd__tapvpwrvgnd_1
XTAP_325 vssd1 vccd1 sky130_fd_sc_hd__tapvpwrvgnd_1
XTAP_358 vssd1 vccd1 sky130_fd_sc_hd__tapvpwrvgnd_1
X_3241_ net561 vssd1 vssd1 vccd1 vccd1 _1622_ sky130_fd_sc_hd__clkbuf_1
XTAP_369 vssd1 vccd1 sky130_fd_sc_hd__tapvpwrvgnd_1
X_3172_ u_audio.counter\[5\] u_audio.counter\[4\] _1585_ vssd1 vssd1 vccd1 vccd1 _1587_
+ sky130_fd_sc_hd__and3_1
X_2123_ u_timer.threshold_reg\[28\] vssd1 vssd1 vccd1 vccd1 _0582_ sky130_fd_sc_hd__inv_2
XFILLER_0_16_61 vssd1 vssd1 vccd1 vccd1 sky130_fd_sc_hd__fill_2
XFILLER_0_16_83 vssd1 vssd1 vccd1 vccd1 sky130_fd_sc_hd__fill_1
XFILLER_0_64_509 vssd1 vssd1 vccd1 vccd1 sky130_fd_sc_hd__fill_1
X_2956_ _1143_ _1144_ vssd1 vssd1 vccd1 vccd1 _1414_ sky130_fd_sc_hd__and2_2
X_2887_ _1278_ _1344_ _1282_ vssd1 vssd1 vccd1 vccd1 _1345_ sky130_fd_sc_hd__a21oi_2
X_4626_ clknet_leaf_9_clk _0427_ vssd1 vssd1 vccd1 vccd1 u_core.u_regfile.rf\[1\]\[28\]
+ sky130_fd_sc_hd__dfxtp_1
Xhold510 u_timer.threshold_reg\[8\] vssd1 vssd1 vccd1 vccd1 net543 sky130_fd_sc_hd__dlygate4sd3_1
XFILLER_0_12_152 vssd1 vssd1 vccd1 vccd1 sky130_fd_sc_hd__fill_2
XFILLER_0_12_141 vssd1 vssd1 vccd1 vccd1 sky130_fd_sc_hd__decap_3
X_4557_ clknet_leaf_18_clk _0358_ vssd1 vssd1 vccd1 vccd1 u_core.u_regfile.rf\[28\]\[23\]
+ sky130_fd_sc_hd__dfxtp_1
Xhold521 u_core.u_regfile.rf\[31\]\[30\] vssd1 vssd1 vccd1 vccd1 net554 sky130_fd_sc_hd__dlygate4sd3_1
X_3508_ net407 vssd1 vssd1 vccd1 vccd1 _1759_ sky130_fd_sc_hd__clkbuf_1
X_4488_ clknet_leaf_26_clk _0289_ vssd1 vssd1 vccd1 vccd1 u_core.u_regfile.rf\[30\]\[18\]
+ sky130_fd_sc_hd__dfxtp_1
X_3439_ _1479_ vssd1 vssd1 vccd1 vccd1 _1715_ sky130_fd_sc_hd__clkbuf_4
XTAP_870 vssd1 vccd1 sky130_fd_sc_hd__tapvpwrvgnd_1
XTAP_892 vssd1 vccd1 sky130_fd_sc_hd__tapvpwrvgnd_1
XTAP_881 vssd1 vccd1 sky130_fd_sc_hd__tapvpwrvgnd_1
XFILLER_0_55_509 vssd1 vssd1 vccd1 vccd1 sky130_fd_sc_hd__fill_1
XFILLER_0_23_439 vssd1 vssd1 vccd1 vccd1 sky130_fd_sc_hd__decap_3
XFILLER_0_50_203 vssd1 vssd1 vccd1 vccd1 sky130_fd_sc_hd__fill_1
Xoutput6 net6 vssd1 vssd1 vccd1 vccd1 gpio_pins[3] sky130_fd_sc_hd__clkbuf_4
XFILLER_0_50_269 vssd1 vssd1 vccd1 vccd1 sky130_fd_sc_hd__fill_1
XFILLER_0_53_15 vccd1 vssd1 vccd1 vssd1 sky130_ef_sc_hd__decap_12
X_2810_ _1262_ _0711_ _0716_ _0706_ _1267_ vssd1 vssd1 vccd1 vccd1 _1268_ sky130_fd_sc_hd__a41oi_4
X_3790_ _1876_ _1862_ net65 vssd1 vssd1 vccd1 vccd1 _1891_ sky130_fd_sc_hd__o21ai_1
X_2741_ _0687_ u_core.u_regfile.rf\[31\]\[17\] vssd1 vssd1 vccd1 vccd1 _1199_ sky130_fd_sc_hd__and2_1
XFILLER_0_26_277 vssd1 vssd1 vccd1 vccd1 sky130_fd_sc_hd__decap_4
X_4411_ clknet_leaf_42_clk _0222_ vssd1 vssd1 vccd1 vccd1 u_core.u_regfile.rf\[29\]\[15\]
+ sky130_fd_sc_hd__dfxtp_1
X_2672_ _1113_ _1114_ _1129_ vssd1 vssd1 vccd1 vccd1 _1130_ sky130_fd_sc_hd__nor3_1
X_4342_ clknet_leaf_31_clk _0153_ vssd1 vssd1 vccd1 vccd1 u_core.u_regfile.rf\[5\]\[10\]
+ sky130_fd_sc_hd__dfxtp_1
X_4273_ clknet_leaf_49_clk _0084_ vssd1 vssd1 vccd1 vccd1 u_core.u_regfile.rf\[6\]\[5\]
+ sky130_fd_sc_hd__dfxtp_1
X_3224_ _1613_ vssd1 vssd1 vccd1 vccd1 _0069_ sky130_fd_sc_hd__clkbuf_1
.ends
